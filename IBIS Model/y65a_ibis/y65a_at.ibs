| y65a_at.ibs * IBIS 4.2 Model
| 128Mb SDR SDRAM - Die Revision "L"
| This Model is valid for Automotive Temperature Range -40C<=Tc<=105C
| Valid for PC100-167 operation (Clock rates of 100/133/143/167MHz)
| Part Number   VDD/VDDQ   Architecture   Package
| MT48LC16M8A2P   3.3V/3.3V   16 Meg x 8   54-pin TSOP
| MT48LC8M16A2P   3.3V/3.3V   8 Meg x 16   54-pin TSOP
| MT48LC16M8A2BB   3.3V/3.3V   16 Meg x 8   60-ball FBGA
| MT48LC8M16A2B4   3.3V/3.3V   8 Meg x 16   54-ball VFBGA
| MT48LC4M32B2P   3.3V/3.3V   4 Meg x 32   86-pin TSOP
| MT48LC4M32B2B5   3.3V/3.3V   4 Meg x 32   90-ball VFBGA
[IBIS Ver]   4.2
[File name]   y65a_at.ibs
[File Rev]   2.1
[Date]   09/03/2019
[Source]   From silicon level SPICE model at Micron Technology, Inc.
   For support contact your local Micron FAE/Sales contacts
   (more information at https://www.micron.com/support/sales-network )
[Notes]   Rev 1.0: 12/13/2010
   - First revision pre-silicon model from parasitic extracted netlist.
   - Typ and slow corner V-t curves in the following DQ model
   are shifted relative to strong corner V-t curve
   to contain all 3 corners within the given V-t window.
   See table below.
   Models   Typ   Slow   V-t duration
   DQ   -400ps   -400ps   9.00ns
   - Due to the shift in typ and slow corners, the V-t curves
   may overlap each other. This does not effect the accuracy
   of the IBIS data.
   Rev 2.0: 08/25/2011
   - Matched models to measurements.
   - Updated C_Comp values for all models.
   - Fixed TSOP package data.
   - Slow corner V-t curves in the following DQ model
   is shifted relative to typical and strong corner V-t curve
   to contain all 3 corners within the given V-t window.
   See table below.
   Models   Slow   V-t duration
   DQ   -400ps   6.00ns
   Rev 2.1: 09/03/2019
   - Fixed Define Package Model Capacitance Matrix data
   - Updated package codes
   General Notes:
   -L_pin values in the [Pin] sections are loop inductance and
   include the mutual inductance to appropriate POWER/GND
   return paths.  POWER/GND parasitics are modeled in the
   [Package Model]s.
| IBIS Quality Specification 2.0 Summary
| IQ Score: IQ3MS
| See Micron IBIS Model Quality Report and Quality Checklist
| for full IQ details
[Disclaimer]  This software code and all associated documentation, comments
              or other information (collectively "Software") is provided
              "AS IS" without warranty of any kind. MICRON TECHNOLOGY, INC.
              ("MTI") EXPRESSLY DISCLAIMS ALL WARRANTIES EXPRESS OR IMPLIED,
              INCLUDING BUT NOT LIMITED TO, NONINFRINGEMENT OF THIRD PARTY
              RIGHTS, AND ANY IMPLIED WARRANTIES OF MERCHANTABILITY OR
              FITNESS FOR ANY PARTICULAR PURPOSE. MTI DOES NOT WARRANT THAT
              THE SOFTWARE WILL MEET YOUR REQUIREMENTS, OR THAT THE
              OPERATION OF THE SOFTWARE WILL BE UNINTERRUPTED OR ERROR-FREE.
              FURTHERMORE, MTI DOES NOT MAKE ANY REPRESENTATIONS REGARDING
              THE USE OR THE RESULTS OF THE USE OF THE SOFTWARE IN TERMS OF
              ITS CORRECTNESS, ACCURACY, RELIABILITY, OR OTHERWISE. THE
              ENTIRE RISK ARISING OUT OF USE OR PERFORMANCE OF THE SOFTWARE
              REMAINS WITH YOU. IN NO EVENT SHALL MTI, ITS AFFILIATED
              COMPANIES OR THEIR SUPPLIERS BE LIABLE FOR ANY DIRECT,
              INDIRECT, CONSEQUENTIAL, INCIDENTAL, OR SPECIAL DAMAGES
              (INCLUDING, WITHOUT LIMITATION, DAMAGES FOR LOSS OF PROFITS,
              BUSINESS INTERRUPTION, OR LOSS OF INFORMATION) ARISING OUT OF
              YOUR USE OF OR INABILITY TO USE THE SOFTWARE, EVEN IF MTI HAS
              BEEN ADVISED OF THE POSSIBILITY OF SUCH DAMAGES. Because some
              jurisdictions prohibit the exclusion or limitation of
              liability for consequential or incidental damages, the above
              limitation may not apply to you.
[Copyright]   Copyright 2019 Micron Technology, Inc. All rights reserved.
|   COMPONENT: MT48LC16M8A2P
[Component]   MT48LC16M8A2P
[Package Model] y65a_x16_tsop
[Manufacturer]  Micron Technology, Inc.
[Package]  | TSOP package
R_pkg   106.21m   49.85m   136.51m
L_pkg   5.47nH   2.71nH   7.17nH
C_pkg   0.74pF   0.40pF   0.94pF
[Pin]   signal_name model_name   R_pin   L_pin   C_pin
1   VDD   POWER
2   DQ0   DQ   101.59m   4.54nH   0.78pF
3   VDDQ   POWER
4   NC   NC
5   DQ1   DQ   73.64m   3.48nH   0.59pF
6   VSSQ   GND
7   NC   NC
8   DQ2   DQ   60.22m   2.71nH   0.46pF
9   VDDQ   POWER
10   NC   NC
11   DQ3   DQ   49.99m   3.05nH   0.40pF
12   VSSQ   GND
13   NC   NC
14   VDD   POWER
15   NC   NC
16   WE#   INPUT   92.46m   4.40nH   0.63pF
17   CAS#   INPUT   98.49m   4.98nH   0.67pF
18   RAS#   INPUT   105.71m   5.45nH   0.72pF
19   CS#   INPUT   112.88m   5.87nH   0.76pF
20   BA0   INPUT   120.18m   6.23nH   0.80pF
21   BA1   INPUT   125.54m   6.54nH   0.84pF
22   A10   INPUT   130.37m   6.82nH   0.88pF
23   A0   INPUT   134.00m   7.02nH   0.91pF
24   A1   INPUT   136.01m   7.17nH   0.94pF
25   A2   INPUT   134.96m   7.11nH   0.93pF
26   A3   INPUT   120.05m   6.44nH   0.87pF
27   VDD   POWER
28   VSS   GND
29   A4   INPUT   120.23m   6.44nH   0.87pF
30   A5   INPUT   135.01m   7.12nH   0.93pF
31   A6   INPUT   136.51m   7.17nH   0.94pF
32   A7   INPUT   134.33m   7.01nH   0.91pF
33   A8   INPUT   130.37m   6.81nH   0.88pF
34   A9   INPUT   125.60m   6.55nH   0.84pF
35   A11   INPUT   119.28m   6.23nH   0.80pF
36   NC   NC
37   CKE   INPUT   104.94m   5.47nH   0.71pF
38   CLK   CLK_INPUT   98.20m   4.98nH   0.68pF
39   DQM   DM_INPUT   89.95m   4.92nH   0.63pF
40   NC   NC
41   VSS   GND
42   NC   NC
43   VDDQ   POWER
44   DQ4   DQ   49.85m   3.05nH   0.40pF
45   NC   NC
46   VSSQ   GND
47   DQ5   DQ   60.05m   2.71nH   0.46pF
48   NC   NC
49   VDDQ   POWER
50   DQ6   DQ   73.53m   3.47nH   0.59pF
51   NC   NC
52   VSSQ   GND
53   DQ7   DQ   101.77m   4.54nH   0.78pF
54   VSS   GND
|***********************PIN MAPPING*****************************************
[Pin Mapping] pulldown_ref pullup_ref gnd_clamp_ref power_clamp_ref ext_ref
1   NC   PWRBUS1   |PWRBUS1 is VDD
2   GNDBUS2   PWRBUS2   GNDBUS2   PWRBUS2
3   NC   PWRBUS2   |PWRBUS2 is VDDQ
4   NC   NC
5   GNDBUS2   PWRBUS2   GNDBUS2   PWRBUS2
6   GNDBUS2   NC   |GNDBUS2 is VSSQ
7   NC   NC
8   GNDBUS2   PWRBUS2   GNDBUS2   PWRBUS2
9   NC   PWRBUS2
10   NC   NC
11   GNDBUS2   PWRBUS2   GNDBUS2   PWRBUS2
12   GNDBUS2   NC
13   NC   NC
14   NC   PWRBUS1
15   NC   NC
16   NC   NC   GNDBUS1   PWRBUS1
17   NC   NC   GNDBUS1   PWRBUS1
18   NC   NC   GNDBUS1   PWRBUS1
19   NC   NC   GNDBUS1   PWRBUS1
20   NC   NC   GNDBUS1   PWRBUS1
21   NC   NC   GNDBUS1   PWRBUS1
22   NC   NC   GNDBUS1   PWRBUS1
23   NC   NC   GNDBUS1   PWRBUS1
24   NC   NC   GNDBUS1   PWRBUS1
25   NC   NC   GNDBUS1   PWRBUS1
26   NC   NC   GNDBUS1   PWRBUS1
27   NC   PWRBUS1
28   GNDBUS1   NC   |GNDBUS1 is VSS
29   NC   NC   GNDBUS1   PWRBUS1
30   NC   NC   GNDBUS1   PWRBUS1
31   NC   NC   GNDBUS1   PWRBUS1
32   NC   NC   GNDBUS1   PWRBUS1
33   NC   NC   GNDBUS1   PWRBUS1
34   NC   NC   GNDBUS1   PWRBUS1
35   NC   NC   GNDBUS1   PWRBUS1
36   NC   NC
37   NC   NC   GNDBUS1   PWRBUS1
38   NC   NC   GNDBUS1   PWRBUS1
39   NC   NC   GNDBUS2   PWRBUS2
40   NC   NC
41   GNDBUS1   NC
42   NC   NC
43   NC   PWRBUS2
44   GNDBUS2   PWRBUS2   GNDBUS2   PWRBUS2
45   NC   NC
46   GNDBUS2   NC
47   GNDBUS2   PWRBUS2   GNDBUS2   PWRBUS2
48   NC   NC
49   NC   PWRBUS2
50   GNDBUS2   PWRBUS2   GNDBUS2   PWRBUS2
51   NC   NC
52   GNDBUS2   NC
53   GNDBUS2   PWRBUS2   GNDBUS2   PWRBUS2
54   GNDBUS1   NC
|   COMPONENT: MT48LC8M16A2P
[Component]   MT48LC8M16A2P
[Package Model] y65a_x16_tsop
[Manufacturer]  Micron Technology, Inc.
[Package]  | TSOP package
|   typ   min   max
R_pkg   97.48m   49.85m   136.51m
L_pkg   4.97nH   2.70nH   7.17nH
C_pkg   0.69pF   0.40pF   0.94pF
[Pin]   signal_name model_name   R_pin   L_pin   C_pin
1   VDD   POWER
2   DQ0   DQ   101.59m   4.54nH   0.78pF
3   VDDQ   POWER
4   DQ1   DQ   83.67m   3.69nH   0.65pF
5   DQ2   DQ   73.64m   3.48nH   0.59pF
6   VSSQ   GND
7   DQ3   DQ   59.51m   3.02nH   0.45pF
8   DQ4   DQ   60.22m   2.71nH   0.46pF
9   VDDQ   POWER
10   DQ5   DQ   57.35m   2.70nH   0.47pF
11   DQ6   DQ   49.99m   3.05nH   0.40pF
12   VSSQ   GND
13   DQ7   DQ   64.80m   3.20nH   0.51pF
14   VDD   POWER
15   DQML   DM_INPUT   83.20m   4.56nH   0.58pF
16   WE#   INPUT   92.46m   4.40nH   0.63pF
17   CAS#   INPUT   98.49m   4.98nH   0.67pF
18   RAS#   INPUT   105.71m   5.45nH   0.72pF
19   CS#   INPUT   112.88m   5.87nH   0.76pF
20   BA0   INPUT   120.18m   6.23nH   0.80pF
21   BA1   INPUT   125.54m   6.54nH   0.84pF
22   A10   INPUT   130.37m   6.82nH   0.88pF
23   A0   INPUT   134.00m   7.02nH   0.91pF
24   A1   INPUT   136.01m   7.17nH   0.94pF
25   A2   INPUT   134.96m   7.11nH   0.93pF
26   A3   INPUT   120.05m   6.44nH   0.87pF
27   VDD   POWER
28   VSS   GND
29   A4   INPUT   120.23m   6.44nH   0.87pF
30   A5   INPUT   135.01m   7.12nH   0.93pF
31   A6   INPUT   136.51m   7.17nH   0.94pF
32   A7   INPUT   134.33m   7.01nH   0.91pF
33   A8   INPUT   130.37m   6.81nH   0.88pF
34   A9   INPUT   125.60m   6.55nH   0.84pF
35   A11   INPUT   119.28m   6.23nH   0.80pF
36   NC   NC
37   CKE   INPUT   104.94m   5.47nH   0.71pF
38   CLK   CLK_INPUT   98.20m   4.98nH   0.68pF
39   DQMH   DM_INPUT   89.95m   4.92nH   0.63pF
40   NC   NC
41   VSS   GND
42   DQ8   DQ   66.72m   3.21nH   0.50pF
43   VDDQ   POWER
44   DQ9   DQ   49.85m   3.05nH   0.40pF
45   DQ10   DQ   57.22m   2.70nH   0.47pF
46   VSSQ   GND
47   DQ11   DQ   60.05m   2.71nH   0.46pF
48   DQ12   DQ   59.34m   3.02nH   0.45pF
49   VDDQ   POWER
50   DQ13   DQ   73.53m   3.47nH   0.59pF
51   DQ14   DQ   83.71m   3.69nH   0.65pF
52   VSSQ   GND
53   DQ15   DQ   101.77m   4.54nH   0.78pF
54   VSS   GND
|***********************PIN MAPPING*****************************************
[Pin Mapping] pulldown_ref pullup_ref gnd_clamp_ref power_clamp_ref ext_ref
1   NC   PWRBUS1   |PWRBUS1 is VDD
2   GNDBUS2   PWRBUS2   GNDBUS2   PWRBUS2
3   NC   PWRBUS2   |PWRBUS2 is VDDQ
4   GNDBUS2   PWRBUS2   GNDBUS2   PWRBUS2
5   GNDBUS2   PWRBUS2   GNDBUS2   PWRBUS2
6   GNDBUS2   NC   |GNDBUS2 is VSSQ
7   GNDBUS2   PWRBUS2   GNDBUS2   PWRBUS2
8   GNDBUS2   PWRBUS2   GNDBUS2   PWRBUS2
9   NC   PWRBUS2
10   GNDBUS2   PWRBUS2   GNDBUS2   PWRBUS2
11   GNDBUS2   PWRBUS2   GNDBUS2   PWRBUS2
12   GNDBUS2   NC
13   GNDBUS2   PWRBUS2   GNDBUS2   PWRBUS2
14   NC   PWRBUS1
15   NC   NC   GNDBUS2   PWRBUS2
16   NC   NC   GNDBUS1   PWRBUS1
17   NC   NC   GNDBUS1   PWRBUS1
18   NC   NC   GNDBUS1   PWRBUS1
19   NC   NC   GNDBUS1   PWRBUS1
20   NC   NC   GNDBUS1   PWRBUS1
21   NC   NC   GNDBUS1   PWRBUS1
22   NC   NC   GNDBUS1   PWRBUS1
23   NC   NC   GNDBUS1   PWRBUS1
24   NC   NC   GNDBUS1   PWRBUS1
25   NC   NC   GNDBUS1   PWRBUS1
26   NC   NC   GNDBUS1   PWRBUS1
27   NC   PWRBUS1
28   GNDBUS1   NC   |GNDBUS1 is VSS
29   NC   NC   GNDBUS1   PWRBUS1
30   NC   NC   GNDBUS1   PWRBUS1
31   NC   NC   GNDBUS1   PWRBUS1
32   NC   NC   GNDBUS1   PWRBUS1
33   NC   NC   GNDBUS1   PWRBUS1
34   NC   NC   GNDBUS1   PWRBUS1
35   NC   NC   GNDBUS1   PWRBUS1
36   NC   NC
37   NC   NC   GNDBUS1   PWRBUS1
38   NC   NC   GNDBUS1   PWRBUS1
39   NC   NC   GNDBUS2   PWRBUS2
40   NC   NC
41   GNDBUS1   NC
42   GNDBUS2   PWRBUS2   GNDBUS2   PWRBUS2
43   NC   PWRBUS2
44   GNDBUS2   PWRBUS2   GNDBUS2   PWRBUS2
45   GNDBUS2   PWRBUS2   GNDBUS2   PWRBUS2
46   GNDBUS2   NC
47   GNDBUS2   PWRBUS2   GNDBUS2   PWRBUS2
48   GNDBUS2   PWRBUS2   GNDBUS2   PWRBUS2
49   NC   PWRBUS2
50   GNDBUS2   PWRBUS2   GNDBUS2   PWRBUS2
51   GNDBUS2   PWRBUS2   GNDBUS2   PWRBUS2
52   GNDBUS2   NC
53   GNDBUS2   PWRBUS2   GNDBUS2   PWRBUS2
54   GNDBUS1   NC
|   COMPONENT: MT48LC16M8A2BB  (60-Ball FBGA)
[Component]   MT48LC16M8A2BB
[Package Model] y65a_x8_fbga
[Manufacturer]  Micron Technology, Inc.
[Package]  | 8mm x 16mm FBGA
|   typ   min   max
R_pkg   177.63m   110.37m   218.90m
L_pkg   3.92nH   2.42nH   5.04nH
C_pkg   0.96pF   0.67pF   1.26pF
[Pin]   signal_name model_name   R_pin   L_pin   C_pin
A1   DQ7   DQ   132.26m   3.38nH   1.01pF
A2   VSS   GND
A7   VDD   POWER
A8   DQ0   DQ   138.76m   3.30nH   1.02pF
B1   NC   NC
B2   VSSQ   GND
B7   VDDQ   POWER
B8   NC   NC
C1   VDDQ   POWER
C2   DQ6   DQ   110.37m   2.42nH   0.93pF
C7   DQ1   DQ   119.17m   2.87nH   0.97pF
C8   VSSQ   GND
D1   DQ5   DQ   129.03m   2.78nH   1.16pF
D2   NC   NC
D7   NC   NC
D8   DQ2   DQ   138.47m   3.03nH   1.24pF
E1   NC   NC
E2   VSSQ   GND
E7   VDDQ   POWER
E8   NC   NC
F1   VDDQ   POWER
F2   DQ4   DQ   138.99m   2.97nH   1.26pF
F7   DQ3   DQ   135.15m   2.99nH   1.23pF
F8   VSSQ   GND
G1   NC   NC
G2   NC   NC
G7   NC   NC
G8   NC   NC
H1   NC   NC
H2   VSS   GND
H7   VDD   POWER
H8   NC   NC
J1   NC   NC
J2   DQM   DM_INPUT   166.40m   3.24nH   0.72pF
J7   WE#   INPUT   160.53m   3.24nH   0.67pF
J8   CAS#   INPUT   163.17m   3.33nH   0.69pF
K1   NC   NC
K2   CLK   CLK_INPUT   181.57m   3.69nH   0.83pF
K7   RAS#   INPUT   171.19m   3.22nH   0.75pF
K8   NC   NC
L1   NC   NC
L2   CKE   INPUT   195.47m   4.31nH   0.90pF
L7   NC   NC
L8   CS#   INPUT   190.94m   4.42nH   0.86pF
M1   A11   INPUT   201.29m   4.41nH   0.95pF
M2   A9   INPUT   186.68m   3.98nH   0.88pF
M7   BA1   INPUT   190.31m   4.18nH   0.90pF
M8   BA0   INPUT   202.94m   4.69nH   0.94pF
N1   A8   INPUT   210.06m   4.68nH   1.02pF
N2   A7   INPUT   194.00m   4.26nH   0.94pF
N7   A0   INPUT   199.42m   4.46nH   0.96pF
N8   A10   INPUT   216.49m   4.89nH   1.07pF
P1   A6   INPUT   215.89m   4.83nH   1.08pF
P2   A5   INPUT   206.74m   4.48nH   1.00pF
P7   A2   INPUT   202.14m   4.54nH   0.95pF
P8   A1   INPUT   218.90m   5.04nH   1.07pF
R1   A4   INPUT   212.01m   4.48nH   1.03pF
R2   VSS   GND
R7   VDD   POWER
R8   A3   INPUT   207.93m   4.74nH   0.98pF
|***********************PIN MAPPING*****************************************
[Pin Mapping] pulldown_ref pullup_ref gnd_clamp_ref power_clamp_ref ext_ref
A1   GNDBUS2   PWRBUS2   GNDBUS2   PWRBUS2
A2   GNDBUS1   NC   |GNDBUS1 is VSS
A7   NC   PWRBUS1   |PWRBUS1 is VDD
A8   GNDBUS2   PWRBUS2   GNDBUS2   PWRBUS2
B1   NC   NC
B2   GNDBUS2   NC   |GNDBUS2 is VSSQ
B7   NC   PWRBUS2   |PWRBUS2 is VDDQ
B8   NC   NC
C1   NC   PWRBUS2
C2   GNDBUS2   PWRBUS2   GNDBUS2   PWRBUS2
C7   GNDBUS2   PWRBUS2   GNDBUS2   PWRBUS2
C8   GNDBUS2   NC
D1   GNDBUS2   PWRBUS2   GNDBUS2   PWRBUS2
D2   NC   NC
D7   NC   NC
D8   GNDBUS2   PWRBUS2   GNDBUS2   PWRBUS2
E1   NC   NC
E2   GNDBUS2   NC
E7   NC   PWRBUS2
E8   NC   NC
F1   NC   PWRBUS2
F2   GNDBUS2   PWRBUS2   GNDBUS2   PWRBUS2
F7   GNDBUS2   PWRBUS2   GNDBUS2   PWRBUS2
F8   GNDBUS2   NC
G1   NC   NC
G2   NC   NC
G7   NC   NC
G8   NC   NC
H1   NC   NC
H2   GNDBUS1   NC
H7   NC   PWRBUS1
H8   NC   NC
J1   NC   NC
J2   NC   NC   GNDBUS2   PWRBUS2
J7   NC   NC   GNDBUS1   PWRBUS1
J8   NC   NC   GNDBUS1   PWRBUS1
K1   NC   NC
K2   NC   NC   GNDBUS1   PWRBUS1
K7   NC   NC   GNDBUS1   PWRBUS1
K8   NC   NC
L1   NC   NC
L2   NC   NC   GNDBUS1   PWRBUS1
L7   NC   NC
L8   NC   NC   GNDBUS1   PWRBUS1
M1   NC   NC   GNDBUS1   PWRBUS1
M2   NC   NC   GNDBUS1   PWRBUS1
M7   NC   NC   GNDBUS1   PWRBUS1
M8   NC   NC   GNDBUS1   PWRBUS1
N1   NC   NC   GNDBUS1   PWRBUS1
N2   NC   NC   GNDBUS1   PWRBUS1
N7   NC   NC   GNDBUS1   PWRBUS1
N8   NC   NC   GNDBUS1   PWRBUS1
P1   NC   NC   GNDBUS1   PWRBUS1
P2   NC   NC   GNDBUS1   PWRBUS1
P7   NC   NC   GNDBUS1   PWRBUS1
P8   NC   NC   GNDBUS1   PWRBUS1
R1   NC   NC   GNDBUS1   PWRBUS1
R2   GNDBUS1   NC
R7   NC   PWRBUS1
R8   NC   NC   GNDBUS1   PWRBUS1
|   COMPONENT: MT48LC8M16A2B4   (54-Ball VFBGA)
[Component]   MT48LC8M16A2B4
[Package Model] y65a_x16_fbga
[Manufacturer]  Micron Technology, Inc.
[Package]  | 8mm x 8mm FBGA
|   typ   min   max
R_pkg   244.0m   174.2m   305.8m
L_pkg   3.73nH   2.49nH   4.76nH
C_pkg   0.83pF   0.63pF   1.09pF
[Pin]   signal_name model_name   R_pin   L_pin   C_pin
A1   VSS   GND
A2   DQ15   DQ   197.9m   2.929nH   0.775pF
A3   VSSQ   GND
A7   VDDQ   POWER
A8   DQ0   DQ   174.2m   2.486nH   0.657pF
A9   VDD   POWER
B1   DQ14   DQ   249.7m   3.710nH   0.971pF
B2   DQ13   DQ   212.2m   3.249nH   0.821pF
B3   VDDQ   POWER
B7   VSSQ   GND
B8   DQ2   DQ   198.8m   2.930nH   0.774pF
B9   DQ1   DQ   211.5m   3.246nH   0.813pF
C1   DQ12   DQ   267.9m   4.202nH   1.005pF
C2   DQ11   DQ   250.1m   3.718nH   0.963pF
C3   VSSQ   GND
C7   VDDQ   POWER
C8   DQ4   DQ   233.7m   3.511nH   0.904pF
C9   DQ3   DQ   241.4m   3.450nH   0.933pF
D1   DQ10   DQ   297.4m   4.491nH   1.093pF
D2   DQ9   DQ   275.2m   4.353nH   1.006pF
D3   VDDQ   POWER
D7   VSSQ   GND
D8   DQ6   DQ   261.9m   4.084nH   0.948pF
D9   DQ5   DQ   273.7m   4.329nH   0.992pF
E1   DQ8   DQ   235.6m   3.344nH   0.626pF
E2   NC   NC
E3   VSS   GND
E7   VDD   POWER
E8   LDQM   DM_INPUT   219.8m   3.118nH   0.677pF
E9   DQ7   DQ   240.1m   3.469nH   0.629pF
F1   UDQM   DM_INPUT   285.0m   4.333nH   0.913pF
F2   CLK   CLK_INPUT   233.6m   3.615nH   0.742pF
F3   CKE   INPUT   222.8m   3.455nH   0.704pF
F7   CAS#   INPUT   229.7m   3.612nH   0.750pF
F8   RAS#   INPUT   229.8m   3.586nH   0.741pF
F9   WE#   INPUT   280.8m   4.454nH   0.902pF
G1   NC   NC
G2   A11   INPUT   248.0m   3.765nH   0.793pF
G3   A9   INPUT   214.8m   3.277nH   0.721pF
G7   BA0   INPUT   221.0m   3.394nH   0.683pF
G8   BA1   INPUT   208.6m   3.200nH   0.652pF
G9   CS#   INPUT   281.0m   4.526nH   0.869pF
H1   A8   INPUT   305.8m   4.759nH   1.006pF
H2   A7   INPUT   264.3m   4.049nH   0.857pF
H3   A6   INPUT   218.5m   3.357nH   0.720pF
H7   A0   INPUT   236.4m   3.798nH   0.777pF
H8   A1   INPUT   231.0m   3.581nH   0.755pF
H9   A10   INPUT   290.8m   4.566nH   0.959pF
J1   VSS   GND
J2   A5   INPUT   276.4m   4.191nH   0.902pF
J3   A4   INPUT   231.7m   3.439nH   0.772pF
J7   A3   INPUT   227.3m   3.502nH   0.713pF
J8   A2   INPUT   272.8m   4.250nH   0.890pF
J9   VDD   POWER
|***********************PIN MAPPING*****************************************
[Pin Mapping] pulldown_ref pullup_ref gnd_clamp_ref power_clamp_ref ext_ref
A1   GNDBUS1   NC   |GNDBUS1 is VSS
A2   GNDBUS2   PWRBUS2   GNDBUS2   PWRBUS2
A3   GNDBUS2   NC   |GNDBUS2 is VSSQ
A7   NC   PWRBUS2   |PWRBUS2 is VDDQ
A8   GNDBUS2   PWRBUS2   GNDBUS2   PWRBUS2
A9   NC   PWRBUS1   |PWRBUS1 is VDD
B1   GNDBUS2   PWRBUS2   GNDBUS2   PWRBUS2
B2   GNDBUS2   PWRBUS2   GNDBUS2   PWRBUS2
B3   NC   PWRBUS2
B7   GNDBUS2   NC
B8   GNDBUS2   PWRBUS2   GNDBUS2   PWRBUS2
B9   GNDBUS2   PWRBUS2   GNDBUS2   PWRBUS2
C1   GNDBUS2   PWRBUS2   GNDBUS2   PWRBUS2
C2   GNDBUS2   PWRBUS2   GNDBUS2   PWRBUS2
C3   GNDBUS2   NC
C7   NC   PWRBUS2
C8   GNDBUS2   PWRBUS2   GNDBUS2   PWRBUS2
C9   GNDBUS2   PWRBUS2   GNDBUS2   PWRBUS2
D1   GNDBUS2   PWRBUS2   GNDBUS2   PWRBUS2
D2   GNDBUS2   PWRBUS2   GNDBUS2   PWRBUS2
D3   NC   PWRBUS2
D7   GNDBUS2   NC
D8   GNDBUS2   PWRBUS2   GNDBUS2   PWRBUS2
D9   GNDBUS2   PWRBUS2   GNDBUS2   PWRBUS2
E1   GNDBUS2   PWRBUS2   GNDBUS2   PWRBUS2
E2   NC   NC
E3   GNDBUS1   NC
E7   NC   PWRBUS1
E8   NC   NC   GNDBUS2   PWRBUS2
E9   GNDBUS2   PWRBUS2   GNDBUS2   PWRBUS2
F1   NC   NC   GNDBUS2   PWRBUS2
F2   NC   NC   GNDBUS1   PWRBUS1
F3   NC   NC   GNDBUS1   PWRBUS1
F7   NC   NC   GNDBUS1   PWRBUS1
F8   NC   NC   GNDBUS1   PWRBUS1
F9   NC   NC   GNDBUS1   PWRBUS1
G1   NC   NC
G2   NC   NC   GNDBUS1   PWRBUS1
G3   NC   NC   GNDBUS1   PWRBUS1
G7   NC   NC   GNDBUS1   PWRBUS1
G8   NC   NC   GNDBUS1   PWRBUS1
G9   NC   NC   GNDBUS1   PWRBUS1
H1   NC   NC   GNDBUS1   PWRBUS1
H2   NC   NC   GNDBUS1   PWRBUS1
H3   NC   NC   GNDBUS1   PWRBUS1
H7   NC   NC   GNDBUS1   PWRBUS1
H8   NC   NC   GNDBUS1   PWRBUS1
H9   NC   NC   GNDBUS1   PWRBUS1
J1   GNDBUS1   NC
J2   NC   NC   GNDBUS1   PWRBUS1
J3   NC   NC   GNDBUS1   PWRBUS1
J7   NC   NC   GNDBUS1   PWRBUS1
J8   NC   NC   GNDBUS1   PWRBUS1
J9   NC   PWRBUS1
|   COMPONENT: MT48LC4M32B2P   (86-pin TSOP)
[Component]   MT48LC4M32B2P
[Package Model] y65a_x32_tsop
[Manufacturer]  Micron Technology, Inc.
[Package]  | TSOP package
|   typ   min   max
R_pkg   86.57m   62.17m   116.27m
L_pkg   4.04nH   2.71nH   5.63nH
C_pkg   0.74pF   0.53pF   1.06pF
[Pin]   signal_name model_name   R_pin   L_pin   C_pin
1   VDD   POWER
2   DQ0   DQ   115.86m   4.52nH   1.06pF
3   VDDQ   POWER
4   DQ1   DQ   102.96m   3.77nH   0.93pF
5   DQ2   DQ   95.09m   3.61nH   0.87pF
6   VSSQ   GND
7   DQ3   DQ   78.27m   3.11nH   0.71pF
8   DQ4   DQ   78.13m   2.91nH   0.66pF
9   VDDQ   POWER
10   DQ5   DQ   69.43m   2.71nH   0.62pF
11   DQ6   DQ   62.24m   2.92nH   0.53pF
12   VSSQ   GND
13   DQ7   DQ   84.09m   3.64nH   0.75pF
14   NC   NC
15   VDD   POWER
16   DQM0   INPUT   85.74m   3.49nH   0.73pF
17   WE#   INPUT   86.20m   4.60nH   0.72pF
18   CAS#   INPUT   87.37m   5.15nH   0.71pF
19   RAS#   INPUT   87.45m   5.42nH   0.70pF
20   CS#   INPUT   87.87m   5.56nH   0.69pF
21   A11   INPUT   85.67m   5.55nH   0.70pF
22   BA0   INPUT   92.05m   5.56nH   0.67pF
23   BA1   INPUT   92.09m   5.46nH   0.67pF
24   A10   INPUT   91.69m   5.31nH   0.68pF
25   A0   INPUT   90.92m   5.10nH   0.69pF
26   A1   INPUT   90.31m   4.83nH   0.70pF
27   A2   INPUT   89.72m   4.33nH   0.71pF
28   DQM2   INPUT   88.74m   3.36nH   0.72pF
29   VDD   POWER
30   NC   NC
31   DQ16   DQ   87.79m   4.53nH   0.74pF
32   VSSQ   GND
33   DQ17   DQ   62.28m   3.77nH   0.53pF
34   DQ18   DQ   69.63m   3.62nH   0.62pF
35   VDDQ   POWER
36   DQ19   DQ   78.70m   3.11nH   0.66pF
37   DQ20   DQ   78.75m   2.91nH   0.71pF
38   VSSQ   GND
39   DQ21   DQ   95.27m   2.71nH   0.87pF
40   DQ22   DQ   102.34m   2.93nH   0.93pF
41   VDDQ   POWER
42   DQ23   DQ   113.67m   3.66nH   1.06pF
43   VDD   POWER
44   VSS   GND
45   DQ24   DQ   116.27m   3.57nH   1.06pF
46   VSSQ   GND
47   DQ25   DQ   103.37m   2.94nH   0.93pF
48   DQ26   DQ   95.31m   2.72nH   0.87pF
49   VDDQ   POWER
50   DQ27   DQ   78.34m   2.87nH   0.71pF
51   DQ28   DQ   78.08m   3.05nH   0.66pF
52   VSSQ   GND
53   DQ29   DQ   69.59m   3.41nH   0.62pF
54   DQ30   DQ   62.31m   3.60nH   0.53pF
55   VDDQ   POWER
56   DQ31   DQ   86.94m   4.76nH   0.75pF
57   NC   NC
58   VSS   GND
59   DQM3   INPUT   88.83m   3.50nH   0.72pF
60   A3   INPUT   89.79m   4.63nH   0.71pF
61   A4   INPUT   90.24m   5.19nH   0.70pF
62   A5   INPUT   90.75m   5.48nH   0.69pF
63   A6   INPUT   89.65m   5.61nH   0.68pF
64   A7   INPUT   88.11m   5.63nH   0.68pF
65   A8   INPUT   83.48m   5.52nH   0.68pF
66   A9   INPUT   78.22m   5.34nH   0.67pF
67   CKE   INPUT   81.14m   5.20nH   0.66pF
68   CLK   INPUT   81.35m   4.92nH   0.69pF
69   NC   NC
70   NC   NC
71   DQM1   INPUT   83.81m   3.43nH   0.73pF
72   VSS   GND
73   NC   NC
74   DQ8   DQ   81.19m   3.65nH   0.76pF
75   VDDQ   POWER
76   DQ9   DQ   62.17m   2.94nH   0.53pF
77   DQ10   DQ   69.55m   2.72nH   0.62pF
78   VSSQ   GND
79   DQ11   DQ   78.69m   2.87nH   0.66pF
80   DQ12   DQ   78.70m   3.05nH   0.71pF
81   VDDQ   POWER
82   DQ13   DQ   95.26m   3.41nH   0.87pF
83   DQ14   DQ   102.36m   3.62nH   0.93pF
84   VSSQ   GND
85   DQ15   DQ   114.18m   4.72nH   1.06pF
86   VSS   GND
|***********************PIN MAPPING*****************************************
[Pin Mapping] pulldown_ref pullup_ref gnd_clamp_ref power_clamp_ref ext_ref
1   NC   PWRBUS1   |PWRBUS1 is VDD
2   GNDBUS2   PWRBUS2   GNDBUS2   PWRBUS2
3   NC   PWRBUS2   |PWRBUS2 is VDDQ
4   GNDBUS2   PWRBUS2   GNDBUS2   PWRBUS2
5   GNDBUS2   PWRBUS2   GNDBUS2   PWRBUS2
6   GNDBUS2   NC   |GNDBUS2 is VSSQ
7   GNDBUS2   PWRBUS2   GNDBUS2   PWRBUS2
8   GNDBUS2   PWRBUS2   GNDBUS2   PWRBUS2
9   NC   PWRBUS2
10   GNDBUS2   PWRBUS2   GNDBUS2   PWRBUS2
11   GNDBUS2   PWRBUS2   GNDBUS2   PWRBUS2
12   GNDBUS2   NC
13   GNDBUS2   PWRBUS2   GNDBUS2   PWRBUS2
14   NC   NC
15   NC   PWRBUS1
16   NC   NC   GNDBUS2   PWRBUS2
17   NC   NC   GNDBUS1   PWRBUS1
18   NC   NC   GNDBUS1   PWRBUS1
19   NC   NC   GNDBUS1   PWRBUS1
20   NC   NC   GNDBUS1   PWRBUS1
21   NC   NC   GNDBUS1   PWRBUS1
22   NC   NC   GNDBUS1   PWRBUS1
23   NC   NC   GNDBUS1   PWRBUS1
24   NC   NC   GNDBUS1   PWRBUS1
25   NC   NC   GNDBUS1   PWRBUS1
26   NC   NC   GNDBUS1   PWRBUS1
27   NC   NC   GNDBUS1   PWRBUS1
28   NC   NC   GNDBUS2   PWRBUS2
29   NC   PWRBUS1
30   NC   NC
31   GNDBUS2   PWRBUS2   GNDBUS2   PWRBUS2
32   GNDBUS2   NC
33   GNDBUS2   PWRBUS2   GNDBUS2   PWRBUS2
34   GNDBUS2   PWRBUS2   GNDBUS2   PWRBUS2
35   NC   PWRBUS2
36   GNDBUS2   PWRBUS2   GNDBUS2   PWRBUS2
37   GNDBUS2   PWRBUS2   GNDBUS2   PWRBUS2
38   GNDBUS2   NC
39   GNDBUS2   PWRBUS2   GNDBUS2   PWRBUS2
40   GNDBUS2   PWRBUS2   GNDBUS2   PWRBUS2
41   NC   PWRBUS2
42   GNDBUS2   PWRBUS2   GNDBUS2   PWRBUS2
43   NC   PWRBUS1
44   GNDBUS1   NC   |GNDBUS1 is VSS
45   GNDBUS2   PWRBUS2   GNDBUS2   PWRBUS2
46   GNDBUS2   NC
47   GNDBUS2   PWRBUS2   GNDBUS2   PWRBUS2
48   GNDBUS2   PWRBUS2   GNDBUS2   PWRBUS2
49   NC   PWRBUS2
50   GNDBUS2   PWRBUS2   GNDBUS2   PWRBUS2
51   GNDBUS2   PWRBUS2   GNDBUS2   PWRBUS2
52   GNDBUS2   NC
53   GNDBUS2   PWRBUS2   GNDBUS2   PWRBUS2
54   GNDBUS2   PWRBUS2   GNDBUS2   PWRBUS2
55   NC   PWRBUS2
56   GNDBUS2   PWRBUS2   GNDBUS2   PWRBUS2
57   NC   NC
58   GNDBUS1   NC
59   NC   NC   GNDBUS2   PWRBUS2
60   NC   NC   GNDBUS1   PWRBUS1
61   NC   NC   GNDBUS1   PWRBUS1
62   NC   NC   GNDBUS1   PWRBUS1
63   NC   NC   GNDBUS1   PWRBUS1
64   NC   NC   GNDBUS1   PWRBUS1
65   NC   NC   GNDBUS1   PWRBUS1
66   NC   NC   GNDBUS1   PWRBUS1
67   NC   NC   GNDBUS1   PWRBUS1
68   NC   NC   GNDBUS1   PWRBUS1
69   NC   NC
70   NC   NC
71   NC   NC   GNDBUS2   PWRBUS2
72   GNDBUS1   NC
73   NC   NC
74   GNDBUS2   PWRBUS2   GNDBUS2   PWRBUS2
75   NC   PWRBUS2
76   GNDBUS2   PWRBUS2   GNDBUS2   PWRBUS2
77   GNDBUS2   PWRBUS2   GNDBUS2   PWRBUS2
78   GNDBUS2   NC
79   GNDBUS2   PWRBUS2   GNDBUS2   PWRBUS2
80   GNDBUS2   PWRBUS2   GNDBUS2   PWRBUS2
81   NC   PWRBUS2
82   GNDBUS2   PWRBUS2   GNDBUS2   PWRBUS2
83   GNDBUS2   PWRBUS2   GNDBUS2   PWRBUS2
84   GNDBUS2   NC
85   GNDBUS2   PWRBUS2   GNDBUS2   PWRBUS2
86   GNDBUS1   NC
|   COMPONENT: MT48LC4M32B2B5   (90-Ball VFBGA)
[Component]   MT48LC4M32B2B5
[Package Model] y65a_x32_fbga
[Manufacturer]  Micron Technology, Inc.
[Package]  | 8mm x 13mm VFBGA
|   typ   min   max
R_pkg   156.3m   86.9m   215.6m
L_pkg   2.38nH   1.12nH   3.36nH
C_pkg   0.63pF   0.34pF   1.00pF
[Pin]   signal_name model_name   R_pin   L_pin   C_pin
A1   DQ26   DQ   170.9m   2.894nH   0.812pF
A2   DQ24   DQ   162.8m   2.593nH   0.775pF
A3   VSS   GND
A7   VDD   POWER
A8   DQ23   DQ   160.9m   2.590nH   0.759pF
A9   DQ21   DQ   174.3m   3.001nH   0.871pF
B1   DQ28   DQ   144.9m   2.327nH   0.775pF
B2   VDDQ   POWER
B3   VSSQ   GND
B7   VDDQ   POWER
B8   VSSQ   GND
B9   DQ19   DQ   136.8m   2.158nH   0.768pF
C1   VSSQ   GND
C2   DQ27   DQ   110.3m   1.730nH   0.649pF
C3   DQ25   DQ   109.3m   1.603nH   0.665pF
C7   DQ22   DQ   102.2m   1.573nH   0.654pF
C8   DQ20   DQ   121.2m   1.641nH   0.823pF
C9   VDDQ   POWER
D1   VSSQ   GND
D2   DQ29   DQ   159.9m   2.388nH   1.002pF
D3   DQ30   DQ   117.6m   1.605nH   0.747pF
D7   DQ17   DQ   90.0m   1.146nH   0.670pF
D8   DQ18   DQ   126.3m   1.752nH   0.848pF
D9   VDDQ   POWER
E1   VDDQ   POWER
E2   DQ31   DQ   160.4m   2.004nH   0.480pF
E3   NC   NC
E7   NC   NC
E8   DQ16   DQ   177.5m   2.448nH   0.497pF
E9   VSSQ   GND
F1   VSS   GND
F2   DQM3   INPUT   204.3m   2.744nH   0.642pF
F3   A3   INPUT   215.6m   2.983nH   0.737pF
F7   A2   INPUT   182.4m   2.639nH   0.585pF
F8   DQM2   INPUT   158.7m   2.114nH   0.369pF
F9   VDD   POWER
G1   A4   INPUT   165.8m   2.627nH   0.415pF
G2   A5   INPUT   159.2m   2.377nH   0.472pF
G3   A6   INPUT   175.4m   2.537nH   0.532pF
G7   A10   INPUT   179.0m   2.566nH   0.546pF
G8   A0   INPUT   201.9m   3.012nH   0.622pF
G9   A1   INPUT   179.4m   3.059nH   0.367pF
H1   A7   INPUT   193.4m   3.356nH   0.441pF
H2   A8   INPUT   190.6m   2.868nH   0.621pF
H3   NC   NC
H7   NC   NC
H8   BA1   INPUT   203.4m   2.994nH   0.673pF
H9   A11   INPUT   178.9m   3.134nH   0.339pF
J1   CLK   INPUT   176.8m   3.090nH   0.353pF
J2   CKE   INPUT   172.8m   2.722nH   0.507pF
J3   A9   INPUT   187.8m   2.820nH   0.628pF
J7   BA0   INPUT   191.4m   2.848nH   0.630pF
J8   CS#   INPUT   169.5m   2.671nH   0.497pF
J9   RAS#   INPUT   164.1m   2.833nH   0.371pF
K1   DQM1   INPUT   188.3m   2.954nH   0.454pF
K2   NC   NC
K3   NC   NC
K7   CAS#   INPUT   183.6m   2.662nH   0.602pF
K8   WE#   INPUT   171.2m   2.598nH   0.539pF
K9   DQM0   INPUT   185.2m   3.021nH   0.453pF
L1   VDDQ   POWER
L2   DQ8   DQ   161.4m   2.031nH   0.482pF
L3   VSS   GND
L7   VDD   POWER
L8   DQ7   DQ   161.0m   1.818nH   0.516pF
L9   VSSQ   GND
M1   VSSQ   GND
M2   DQ10   DQ   120.0m   1.585nH   0.816pF
M3   DQ9   DQ   86.9m   1.115nH   0.612pF
M7   DQ6   DQ   88.5m   1.133nH   0.662pF
M8   DQ5   DQ   108.1m   1.622nH   0.656pF
M9   VDDQ   POWER
N1   VSSQ   GND
N2   DQ12   DQ   107.8m   1.541nH   0.736pF
N3   DQ14   DQ   99.8m   1.404nH   0.728pF
N7   DQ1   DQ   104.5m   1.549nH   0.624pF
N8   DQ3   DQ   123.6m   2.076nH   0.663pF
N9   VDDQ   POWER
P1   DQ11   DQ   138.7m   2.083nH   0.805pF
P2   VDDQ   POWER
P3   VSSQ   GND
P7   VDDQ   POWER
P8   VSSQ   GND
P9   DQ4   DQ   161.8m   2.759nH   0.780pF
R1   DQ13   DQ   175.2m   2.941nH   0.876pF
R2   DQ15   DQ   163.1m   2.791nH   0.774pF
R3   VSS   GND
R7   VDD   POWER
R8   DQ0   DQ   172.3m   2.834nH   0.786pF
R9   DQ2   DQ   173.2m   3.034nH   0.812pF
|***********************PIN MAPPING*****************************************
[Pin Mapping] pulldown_ref pullup_ref gnd_clamp_ref power_clamp_ref ext_ref
A1   GNDBUS2   PWRBUS2   GNDBUS2   PWRBUS2
A2   GNDBUS2   PWRBUS2   GNDBUS2   PWRBUS2
A3   GNDBUS1   NC   |GNDBUS1 is VSS
A7   NC   PWRBUS1   |PWRBUS1 is VDD
A8   GNDBUS2   PWRBUS2   GNDBUS2   PWRBUS2
A9   GNDBUS2   PWRBUS2   GNDBUS2   PWRBUS2
B1   GNDBUS2   PWRBUS2   GNDBUS2   PWRBUS2
B2   NC   PWRBUS2   |PWRBUS2 is VDDQ
B3   GNDBUS2   NC   |GNDBUS2 is VSSQ
B7   NC   PWRBUS2
B8   GNDBUS2   NC
B9   GNDBUS2   PWRBUS2   GNDBUS2   PWRBUS2
C1   GNDBUS2   NC
C2   GNDBUS2   PWRBUS2   GNDBUS2   PWRBUS2
C3   GNDBUS2   PWRBUS2   GNDBUS2   PWRBUS2
C7   GNDBUS2   PWRBUS2   GNDBUS2   PWRBUS2
C8   GNDBUS2   PWRBUS2   GNDBUS2   PWRBUS2
C9   NC   PWRBUS2
D1   GNDBUS2   NC
D2   GNDBUS2   PWRBUS2   GNDBUS2   PWRBUS2
D3   GNDBUS2   PWRBUS2   GNDBUS2   PWRBUS2
D7   GNDBUS2   PWRBUS2   GNDBUS2   PWRBUS2
D8   GNDBUS2   PWRBUS2   GNDBUS2   PWRBUS2
D9   NC   PWRBUS2
E1   NC   PWRBUS2
E2   GNDBUS2   PWRBUS2   GNDBUS2   PWRBUS2
E3   NC   NC
E7   NC   NC
E8   GNDBUS2   PWRBUS2   GNDBUS2   PWRBUS2
E9   GNDBUS2   NC
F1   GNDBUS1   NC
F2   NC   NC   GNDBUS2   PWRBUS2
F3   NC   NC   GNDBUS1   PWRBUS1
F7   NC   NC   GNDBUS1   PWRBUS1
F8   NC   NC   GNDBUS2   PWRBUS2
F9   NC   PWRBUS1
G1   NC   NC   GNDBUS1   PWRBUS1
G2   NC   NC   GNDBUS1   PWRBUS1
G3   NC   NC   GNDBUS1   PWRBUS1
G7   NC   NC   GNDBUS1   PWRBUS1
G8   NC   NC   GNDBUS1   PWRBUS1
G9   NC   NC   GNDBUS1   PWRBUS1
H1   NC   NC   GNDBUS1   PWRBUS1
H2   NC   NC   GNDBUS1   PWRBUS1
H3   NC   NC
H7   NC   NC
H8   NC   NC   GNDBUS1   PWRBUS1
H9   NC   NC   GNDBUS1   PWRBUS1
J1   NC   NC   GNDBUS1   PWRBUS1
J2   NC   NC   GNDBUS1   PWRBUS1
J3   NC   NC   GNDBUS1   PWRBUS1
J7   NC   NC   GNDBUS1   PWRBUS1
J8   NC   NC   GNDBUS1   PWRBUS1
J9   NC   NC   GNDBUS1   PWRBUS1
K1   NC   NC   GNDBUS2   PWRBUS2
K2   NC   NC
K3   NC   NC
K7   NC   NC   GNDBUS1   PWRBUS1
K8   NC   NC   GNDBUS1   PWRBUS1
K9   NC   NC   GNDBUS2   PWRBUS2
L1   NC   PWRBUS2
L2   GNDBUS2   PWRBUS2   GNDBUS2   PWRBUS2
L3   GNDBUS1   NC
L7   NC   PWRBUS1
L8   GNDBUS2   PWRBUS2   GNDBUS2   PWRBUS2
L9   GNDBUS2   NC
M1   GNDBUS2   NC
M2   GNDBUS2   PWRBUS2   GNDBUS2   PWRBUS2
M3   GNDBUS2   PWRBUS2   GNDBUS2   PWRBUS2
M7   GNDBUS2   PWRBUS2   GNDBUS2   PWRBUS2
M8   GNDBUS2   PWRBUS2   GNDBUS2   PWRBUS2
M9   NC   PWRBUS2
N1   GNDBUS2   NC
N2   GNDBUS2   PWRBUS2   GNDBUS2   PWRBUS2
N3   GNDBUS2   PWRBUS2   GNDBUS2   PWRBUS2
N7   GNDBUS2   PWRBUS2   GNDBUS2   PWRBUS2
N8   GNDBUS2   PWRBUS2   GNDBUS2   PWRBUS2
N9   NC   PWRBUS2
P1   GNDBUS2   PWRBUS2   GNDBUS2   PWRBUS2
P2   NC   PWRBUS2
P3   GNDBUS2   NC
P7   NC   PWRBUS2
P8   GNDBUS2   NC
P9   GNDBUS2   PWRBUS2   GNDBUS2   PWRBUS2
R1   GNDBUS2   PWRBUS2   GNDBUS2   PWRBUS2
R2   GNDBUS2   PWRBUS2   GNDBUS2   PWRBUS2
R3   GNDBUS1   NC
R7   NC   PWRBUS1
R8   GNDBUS2   PWRBUS2   GNDBUS2   PWRBUS2
R9   GNDBUS2   PWRBUS2   GNDBUS2   PWRBUS2
[Define Package Model]  y65a_x8_fbga
[Manufacturer]  Micron Technology, Inc.
[OEM]   Micron Technology, Inc.
[Description]   60-ball (8mm x 16mm) FBGA
[Number of Pins]   35
[Pin Numbers]
A1
A2
A7
A8
B2
B7
C2
C7
D1
D8
F2
F7
J2
J7
J8
K2
K7
K8
L1
L2
L8
M1
M2
M7
M8
N1
N2
N7
N8
P1
P2
P7
P8
R1
R8
[Model Data]
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[End Model Data]
[End Package Model]
[Define Package Model]  y65a_x16_fbga
[Manufacturer]  Micron Technology, Inc.
[OEM]   Micron Technology, Inc.
[Description]   54-ball (8mm x 8mm) VFBGA
[Number of Pins]   44
[Pin Numbers]
A1
A2
A3
A7
A8
A9
B1
B2
B8
B9
C1
C2
C8
C9
D1
D2
D8
D9
E1
E2
E8
E9
F1
F2
F3
F7
F8
F9
G1
G2
G3
G7
G8
G9
H1
H2
H3
H7
H8
H9
J2
J3
J7
J8
[Model Data]
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[End Model Data]
[End Package Model]
[Define Package Model]  y65a_x16_tsop
[Manufacturer]  Micron Technology, Inc.
[OEM]   Micron Technology, Inc.
[Description]  TSOP package
[Number of Pins]   53
[Pin Numbers]
1
2
3
4
5
6
7
8
9
10
11
12
13
14
15
16
17
18
19
20
21
22
23
24
25
26
27
28
29
30
31
32
33
34
35
36
37
38
39
41
42
43
44
45
46
47
48
49
50
51
52
53
54
[Model Data]
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[End Model Data]
[End Package Model]
[Define Package Model]  y65a_x32_tsop
[Manufacturer]  Micron Technology, Inc.
[OEM]   Micron Technology, Inc.
[Description]  TSOP package
[Number of Pins]   80
[Pin Numbers]
1
2
3
4
5
6
7
8
9
10
11
12
13
15
16
17
18
19
20
21
22
23
24
25
26
27
28
29
31
32
33
34
35
36
37
38
39
40
41
42
43
44
45
46
47
48
49
50
51
52
53
54
55
56
58
59
60
61
62
63
64
65
66
67
68
71
72
74
75
76
77
78
79
80
81
82
83
84
85
86
[Model Data]
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[End Model Data]
[End Package Model]
[Define Package Model]  y65a_x32_fbga
[Manufacturer]  Micron Technology, Inc.
[OEM]   Micron Technology, Inc.
[Description]   90-ball (8mm x 13mm) VFBGA
[Number of Pins]   61
[Pin Numbers]
A1
A2
A3
A7
A8
A9
B1
B2
B3
B9
C2
C3
C7
C8
D2
D3
D7
D8
E2
E8
F2
F3
F7
F8
G1
G2
G3
G7
G8
G9
H1
H2
H8
H9
J1
J2
J3
J7
J8
J9
K1
K2
K7
K8
K9
L2
L8
M2
M3
M7
M8
N2
N3
N7
N8
P1
P9
R1
R2
R8
R9
[Model Data]
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[End Model Data]
[End Package Model]
| Models and submodels in the file (4): DQ (I/O), INPUT (Input), CLK_INPUT (Input), DM_INPUT (Input)
