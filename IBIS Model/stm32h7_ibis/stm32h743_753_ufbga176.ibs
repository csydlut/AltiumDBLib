| IBIS file stm32h743_753_ufbga176.ibs
[IBIS ver]   4.2
[File name]   stm32h743_753_ufbga176.ibs
[File Rev]   2.0
[Date]   10-04-2019
[Source]   Data Created at STMicroelectronics
[Notes]   File originated from ELDO simulations.
[Disclaimer]  This information is for modeling purpose only and is
   not guaranteed.
   The information is subject to change without notice.
[Copyright]   Copyright 2019 STMicroelectronics Inc.
|   Component stm32h743_753_ufbga176
[Component] stm32h743_753_ufbga176
[Manufacturer] STMicroelectronics
[Package]
| variable   typ   min   max
R_pkg   0.285Ohm   0.133Ohm   0.521Ohm
L_pkg   2.052nH   0.647nH   3.710nH
C_pkg   0.595pF   0.311pF   1.449pF
[Pin]   signal_name   model_name   R_pin   L_pin   C_pin   | Comment
A1   PE3   io8_hslv_ft
A2   PE2   io8_hslv_ft
A3   PE1   io8_hslv_ft
A4   PE0   io8_hslv_ft
A5   PB8   io8_hslv_i2c_ft
A6   PB5   io8_ft
A7   PG14   io8_hslv_ft
A8   PG13   io8_hslv_ft
A9   PB4   io8_ft
A10   PB3   io8_ft
A11   PD7   io8_hslv_ft
A12   PC12   io8_hslv_ft
A13   PA15   io8_ft
A14   PA14   io8_ft
A15   PA13   io8_ft
B1   PE4   io8_hslv_ft
B2   PE5   io8_hslv_ft
B3   PE6   io8_hslv_ft
B4   PB9   io8_hslv_i2c_ft
B5   PB7   io8_ft
B6   PB6   io8_i2c_ft
B7   PG15   io8_hslv_ft
B8   PG12   io8_hslv_ft
B9   PG11   io8_hslv_ft
B10   PG10   io8_hslv_ft
B11   PD6   io8_hslv_ft
B12   PD0   io8_hslv_ft
B13   PC11   io8_hslv_ft
B14   PC10   io8_hslv_ft
B15   PA12   io8usb_lsfs_bcd_otg20_ft
C1   VBAT   power
C2   PI7   io8_hslv_ft
C3   PI6   io8_hslv_ft
C4   PI5   io8_hslv_ft
C5   VDD   power
C6   PDR_ON   nc
C7   VDD   power
C8   VDD   power
C9   VDD   power
C10   PG9   io8_hslv_ft
C11   PD5   io8_hslv_ft
C12   PD1   io8_hslv_ft
C13   PI3   io8_hslv_ft
C14   PI2   io8_hslv_ft
C15   PA11   io8usb_lsfs_bcd_otg20_ft
D1   PC13   io8_ft
D2   PI8   io8_ft
D3   PI9   io8_hslv_ft
D4   PI4   io8_hslv_ft
D5   VSS   gnd
D6   BOOT0   vpp_test_hv
D7   VSS   gnd
D8   VSS   gnd
D9   VSS   gnd
D10   PD4   io8_hslv_ft
D11   PD3   io8_hslv_ft
D12   PD2   io8_hslv_ft
D13   PH15   io8_hslv_ft
D14   PI1   io8_hslv_ft
D15   PA10   io8usb_id_otg20_ft
E1   PC14   io8_ft
E2   PF0   io8_i2c_ft
E3   PI10   io8_hslv_ft
E4   PI11   io8_ft
E12   PH13   io8_hslv_ft
E13   PH14   io8_hslv_ft
E14   PI0   io8_hslv_ft
E15   PA9   io8usb_vbus_otg20_ft
F1   PC15_OSC32_OUT   io8_ft
F2   VSS   gnd
F3   VDD   power
F4   PH2   io8_hslv_ft
F6   VSS   gnd
F7   VSS   gnd
F8   VSS   gnd
F9   VSS   gnd
F10   VSS   gnd
F12   VSS   gnd
F13   VCAP   nc
F14   PC9   io8_hslv_i2c_ft
F15   PA8   io8_hslv_i2c_ft
G1   PH0-OSC_IN   io8_ft
G2   VSS   gnd
G3   VDD   power
G4   PH3   io8_hslv_ft
G6   VSS   gnd
G7   VSS   gnd
G8   VSS   gnd
G9   VSS   gnd
G10   VSS   gnd
G12   VSS   gnd
G13   VDD   power
G14   PC8   io8_hslv_ft
G15   PC7   io8_hslv_ft
H1   PH1-OSC_OUT   io8_ft
H2   PF2   io8_ft
H3   PF1   io8_i2c_ft
H4   PH4   io8_i2c_ft
H6   VSS   gnd
H7   VSS   gnd
H8   VSS   gnd
H9   VSS   gnd
H10   VSS   gnd
H12   VSS   gnd
H13   VDD33USB   power
H14   PG8   io8_hslv_ft
H15   PC6   io8_hslv_swp_ft
J1   NRST   ioreset_ft
J2   PF3   io8_hslv_ft
J3   PF4   io8_hslv_ft
J4   PH5   io8_i2c_ft
J6   VSS   gnd
J7   VSS   gnd
J8   VSS   gnd
J9   VSS   gnd
J10   VSS   gnd
J12   VDD   power
J13   VDD   power
J14   PG7   io8_hslv_ft
J15   PG6   io8_hslv_ft
K1   PF7   io8_hslv_ft
K2   PF6   io8_hslv_ft
K3   PF5   io8_hslv_ft
K4   VDD   power
K6   VSS   gnd
K7   VSS   gnd
K8   VSS   gnd
K9   VSS   gnd
K10   VSS   gnd
K12   PH12   io8_hslv_i2c_ft
K13   PG5   io8_hslv_ft
K14   PG4   io8_hslv_ft
K15   PG3   io8_hslv_ft
L1   PF10   io8_hslv_ft
L2   PF9   io8_hslv_ft
L3   PF8   io8_hslv_ft
L4   VSS   gnd
L12   PH11   io8_hslv_i2c_ft
L13   PH10   io8_hslv_ft
L14   PD15   io8_hslv_ft
L15   PG2   io8_hslv_ft
M1   VSSA   nc
M2   PC0   io8_ft
M3   PC1   io8_hslv_ft
M4   PC2_C   io8_ft
M5   PC3_C   io8_ft
M6   PB2   io8_hslv_ft
M7   PG1   io8_hslv_ft
M8   VSS   gnd
M9   VSS   gnd
M10   VCAP   nc
M11   PH6   io8_ft
M12   PH8   io8_hslv_i2c_ft
M13   PH9   io8_hslv_ft
M14   PD14   io8_hslv_ft
M15   PD13   io8_hslv_i2c_ft
N1   VREFM   nc
N2   PA1   io8_hslv_ft
N3   PA0   io8_ft
N4   PA4   io8_ft
N5   PC4   io8_ft
N6   PF13   io8_hslv_ft
N7   PG0   io8_hslv_ft
N8   VDD   power
N9   VDD   power
N10   VDD   power
N11   PE13   io8_hslv_ft
N12   PH7   io8_i2c_ft
N13   PD12   io8_hslv_i2c_ft
N14   PD11   io8_hslv_ft
N15   PD10   io8_hslv_ft
P1   VREFP   nc
P2   PA2   io8_ft
P3   PA6   io8_ft
P4   PA5   io8_hslv_ft
P5   PC5   io8_ft
P6   PF12   io8_hslv_ft
P7   PF15   io8_hslv_i2c_ft
P8   PE8   io8_hslv_ft
P9   PE9   io8_hslv_ft
P10   PE11   io8_hslv_ft
P11   PE14   io8_hslv_ft
P12   PB12   io8usb_id_otg20_ft
P13   PB13   io8usb_vbus_otg20_ft
P14   PD9   io8_hslv_ft
P15   PD8   io8_hslv_ft
R1   VDDA   nc
R2   PA3   io8_hslv_ft
R3   PA7   io8_ft
R4   PB1   io8_ft
R5   PB0   io8_ft
R6   PF11   io8_ft
R7   PF14   io8_hslv_ft
R8   PE7   io8_hslv_ft
R9   PE10   io8_hslv_ft
R10   PE12   io8_hslv_ft
R11   PE15   io8_hslv_ft
R12   PB10   io8_i2c_ft
R13   PB11   io8_i2c_ft
R14   PB14   io8usb_lsfs_bcd_otg20_ft
R15   PB15   io8usb_lsfs_bcd_otg20_ft
[Package Model]   stm32h743_753_ufbga_176
[Pin Mapping]   pulldown_ref   pullup_ref   | Comment
A1   gndio   vddio
A2   gndio   vddio
A3   gndio   vddio
A4   gndio   vddio
A5   gndio   vddio
A6   gndio   vddio
A7   gndio   vddio
A8   gndio   vddio
A9   gndio   vddio
A10   gndio   vddio
A11   gndio   vddio
A12   gndio   vddio
A13   gndio   vddio
A14   gndio   vddio
A15   gndio   vddio
B1   gndio   vddio
B2   gndio   vddio
B3   gndio   vddio
B4   gndio   vddio
B5   gndio   vddio
B6   gndio   vddio
B7   gndio   vddio
B8   gndio   vddio
B9   gndio   vddio
B10   gndio   vddio
B11   gndio   vddio
B12   gndio   vddio
B13   gndio   vddio
B14   gndio   vddio
B15   gndio   vddusb   | Depending on IO Usage
|B15   gndio   vddio   | Depending on IO Usage
C1   nc   vswitch
C2   gndio   vddio
C3   gndio   vddio
C4   gndio   vddio
C5   nc   vddio
C6   nc   nc
C7   nc   vddio
C8   nc   vddio
C9   nc   vddio
C10   gndio   vddio
C11   gndio   vddio
C12   gndio   vddio
C13   gndio   vddio
C14   gndio   vddio
C15   gndio   vddusb   | Depending on IO Usage
|C15   gndio   vddio   | Depending on IO Usage
D1   gndio   vswitch
D2   gndio   vswitch
D3   gndio   vddio
D4   gndio   vddio
D5   gndio   nc
D6   gndio   vddio
D7   gndio   nc
D8   gndio   nc
D9   gndio   nc
D10   gndio   vddio
D11   gndio   vddio
D12   gndio   vddio
D13   gndio   vddio
D14   gndio   vddio
D15   gndio   vddusb   | Depending on IO Usage
|D15   gndio   vddio   | Depending on IO Usage
E1   gndio   vswitch
E2   gndio   vddio
E3   gndio   vddio
E4   gndio   vddio
E12   gndio   vddio
E13   gndio   vddio
E14   gndio   vddio
E15   gndio   vddusb   | Depending on IO Usage
|E15   gndio   vddio   | Depending on IO Usage
F1   gndio   vswitch
F2   gndio   nc
F3   nc   vddio
F4   gndio   vddio
F6   gndio   nc
F7   gndio   nc
F8   gndio   nc
F9   gndio   nc
F10   gndio   nc
F12   gndio   nc
F13   nc   nc
F14   gndio   vddio
F15   gndio   vddio
G1   gndio   vddio
G2   gndio   nc
G3   nc   vddio
G4   gndio   vddio
G6   gndio   nc
G7   gndio   nc
G8   gndio   nc
G9   gndio   nc
G10   gndio   nc
G12   gndio   nc
G13   nc   vddio
G14   gndio   vddio
G15   gndio   vddio
H1   gndio   vddio
H2   gndio   vddio
H3   gndio   vddio
H4   gndio   vddio
H6   gndio   nc
H7   gndio   nc
H8   gndio   nc
H9   gndio   nc
H10   gndio   nc
H12   gndio   nc
H13   nc   vddusb
H14   gndio   vddio
H15   gndio   vddio
J1   gndio   vddio
J2   gndio   vddio
J3   gndio   vddio
J4   gndio   vddio
J6   gndio   nc
J7   gndio   nc
J8   gndio   nc
J9   gndio   nc
J10   gndio   nc
J12   nc   vddio
J13   nc   vddio
J14   gndio   vddio
J15   gndio   vddio
K1   gndio   vddio
K2   gndio   vddio
K3   gndio   vddio
K4   nc   vddio
K6   gndio   nc
K7   gndio   nc
K8   gndio   nc
K9   gndio   nc
K10   gndio   nc
K12   gndio   vddio
K13   gndio   vddio
K14   gndio   vddio
K15   gndio   vddio
L1   gndio   vddio
L2   gndio   vddio
L3   gndio   vddio
L4   gndio   nc
L12   gndio   vddio
L13   gndio   vddio
L14   gndio   vddio
L15   gndio   vddio
M1   nc   nc
M2   gndio   vddio
M3   gndio   vddio
M4   gndio   vddio
M5   gndio   vddio
M6   gndio   vddio
M7   gndio   vddio
M8   gndio   nc
M9   gndio   nc
M10   nc   nc
M11   gndio   vddio
M12   gndio   vddio
M13   gndio   vddio
M14   gndio   vddio
M15   gndio   vddio
N1   nc   nc
N2   gndio   vddio
N3   gndio   vddio
N4   gndio   vddio
N5   gndio   vddio
N6   gndio   vddio
N7   gndio   vddio
N8   nc   vddio
N9   nc   vddio
N10   nc   vddio
N11   gndio   vddio
N12   gndio   vddio
N13   gndio   vddio
N14   gndio   vddio
N15   gndio   vddio
P1   nc   nc
P2   gndio   vddio
P3   gndio   vddio
P4   gndio   vddio
P5   gndio   vddio
P6   gndio   vddio
P7   gndio   vddio
P8   gndio   vddio
P9   gndio   vddio
P10   gndio   vddio
P11   gndio   vddio
P12   gndio   vddusb   | Depending on IO Usage
|P12   gndio   vddio   | Depending on IO Usage
P13   gndio   vddusb   | Depending on IO Usage
|P13   gndio   vddio   | Depending on IO Usage
P14   gndio   vddio
P15   gndio   vddio
R1   nc   nc
R2   gndio   vddio
R3   gndio   vddio
R4   gndio   vddio
R5   gndio   vddio
R6   gndio   vddio
R7   gndio   vddio
R8   gndio   vddio
R9   gndio   vddio
R10   gndio   vddio
R11   gndio   vddio
R12   gndio   vddio
R13   gndio   vddio
R14   gndio   vddusb   | Depending on IO Usage
|R14   gndio   vddio   | Depending on IO Usage
R15   gndio   vddusb   | Depending on IO Usage
|R15   gndio   vddio   | Depending on IO Usage
[Model Selector] io8_ft
io8_ft_hs_1v2  "General purpose IO. 5V tolerant. 1.2V range. High speed."
io8_ft_hs_1v8  "General purpose IO. 5V tolerant. 1.8V range. High speed."
io8_ft_hs_3v3  "General purpose IO. 5V tolerant. 3.3V range. High speed."
io8_ft_fs_1v2  "General purpose IO. 5V tolerant. 1.2V range. Fast speed."
io8_ft_fs_1v8  "General purpose IO. 5V tolerant. 1.8V range. Fast speed."
io8_ft_fs_3v3  "General purpose IO. 5V tolerant. 3.3V range. Fast speed."
io8_ft_ms_1v2  "General purpose IO. 5V tolerant. 1.2V range. Medium speed."
io8_ft_ms_1v8  "General purpose IO. 5V tolerant. 1.8V range. Medium speed."
io8_ft_ms_3v3  "General purpose IO. 5V tolerant. 3.3V range. Medium speed."
io8_ft_ls_1v2  "General purpose IO. 5V tolerant. 1.2V range. Low speed."
io8_ft_ls_1v8  "General purpose IO. 5V tolerant. 1.8V range. Low speed."
io8_ft_ls_3v3  "General purpose IO. 5V tolerant. 3.3V range. Low speed."
[Model Selector] io8_hslv_ft
io8_ft_hs_1v2  "General purpose IO. 5V tolerant. 1.2V range. High speed."
io8_ft_hs_1v8  "General purpose IO. 5V tolerant. 1.8V range. High speed."
io8_ft_hs_3v3  "General purpose IO. 5V tolerant. 3.3V range. High speed."
io8_ft_fs_1v2  "General purpose IO. 5V tolerant. 1.2V range. Fast speed."
io8_ft_fs_1v8  "General purpose IO. 5V tolerant. 1.8V range. Fast speed."
io8_ft_fs_3v3  "General purpose IO. 5V tolerant. 3.3V range. Fast speed."
io8_ft_ms_1v2  "General purpose IO. 5V tolerant. 1.2V range. Medium speed."
io8_ft_ms_1v8  "General purpose IO. 5V tolerant. 1.8V range. Medium speed."
io8_ft_ms_3v3  "General purpose IO. 5V tolerant. 3.3V range. Medium speed."
io8_ft_ls_1v2  "General purpose IO. 5V tolerant. 1.2V range. Low speed."
io8_ft_ls_1v8  "General purpose IO. 5V tolerant. 1.8V range. Low speed."
io8_ft_ls_3v3  "General purpose IO. 5V tolerant. 3.3V range. Low speed."
io8_hslv_ft_hs_1v2  "General purpose IO with low voltage optimization. 5V tolerant. 1.2V range. High speed."
io8_hslv_ft_hs_1v8  "General purpose IO with low voltage optimization. 5V tolerant. 1.8V range. High speed."
io8_hslv_ft_hs_2v5  "General purpose IO with low voltage optimization. 5V tolerant. 2.5V range. High speed."
io8_hslv_ft_fs_1v2  "General purpose IO with low voltage optimization. 5V tolerant. 1.2V range. Fast speed."
io8_hslv_ft_fs_1v8  "General purpose IO with low voltage optimization. 5V tolerant. 1.8V range. Fast speed."
io8_hslv_ft_fs_2v5  "General purpose IO with low voltage optimization. 5V tolerant. 2.5V range. Fast speed."
io8_hslv_ft_ms_1v2  "General purpose IO with low voltage optimization. 5V tolerant. 1.2V range. Medium speed."
io8_hslv_ft_ms_1v8  "General purpose IO with low voltage optimization. 5V tolerant. 1.8V range. Medium speed."
io8_hslv_ft_ms_2v5  "General purpose IO with low voltage optimization. 5V tolerant. 2.5V range. Medium speed."
io8_hslv_ft_ls_1v2  "General purpose IO with low voltage optimization. 5V tolerant. 1.2V range. Low speed."
io8_hslv_ft_ls_1v8  "General purpose IO with low voltage optimization. 5V tolerant. 1.8V range. Low speed."
io8_hslv_ft_ls_2v5  "General purpose IO with low voltage optimization. 5V tolerant. 2.5V range. Low speed."
[Model Selector] io8_hslv_i2c_ft
io8_ft_hs_1v2  "General purpose IO. 5V tolerant. 1.2V range. High speed."
io8_ft_hs_1v8  "General purpose IO. 5V tolerant. 1.8V range. High speed."
io8_ft_hs_3v3  "General purpose IO. 5V tolerant. 3.3V range. High speed."
io8_ft_fs_1v2  "General purpose IO. 5V tolerant. 1.2V range. Fast speed."
io8_ft_fs_1v8  "General purpose IO. 5V tolerant. 1.8V range. Fast speed."
io8_ft_fs_3v3  "General purpose IO. 5V tolerant. 3.3V range. Fast speed."
io8_ft_ms_1v2  "General purpose IO. 5V tolerant. 1.2V range. Medium speed."
io8_ft_ms_1v8  "General purpose IO. 5V tolerant. 1.8V range. Medium speed."
io8_ft_ms_3v3  "General purpose IO. 5V tolerant. 3.3V range. Medium speed."
io8_ft_ls_1v2  "General purpose IO. 5V tolerant. 1.2V range. Low speed."
io8_ft_ls_1v8  "General purpose IO. 5V tolerant. 1.8V range. Low speed."
io8_ft_ls_3v3  "General purpose IO. 5V tolerant. 3.3V range. Low speed."
io8_hslv_ft_hs_1v2  "General purpose IO with low voltage optimization. 5V tolerant. 1.2V range. High speed."
io8_hslv_ft_hs_1v8  "General purpose IO with low voltage optimization. 5V tolerant. 1.8V range. High speed."
io8_hslv_ft_hs_2v5  "General purpose IO with low voltage optimization. 5V tolerant. 2.5V range. High speed."
io8_hslv_ft_fs_1v2  "General purpose IO with low voltage optimization. 5V tolerant. 1.2V range. Fast speed."
io8_hslv_ft_fs_1v8  "General purpose IO with low voltage optimization. 5V tolerant. 1.8V range. Fast speed."
io8_hslv_ft_fs_2v5  "General purpose IO with low voltage optimization. 5V tolerant. 2.5V range. Fast speed."
io8_hslv_ft_ms_1v2  "General purpose IO with low voltage optimization. 5V tolerant. 1.2V range. Medium speed."
io8_hslv_ft_ms_1v8  "General purpose IO with low voltage optimization. 5V tolerant. 1.8V range. Medium speed."
io8_hslv_ft_ms_2v5  "General purpose IO with low voltage optimization. 5V tolerant. 2.5V range. Medium speed."
io8_hslv_ft_ls_1v2  "General purpose IO with low voltage optimization. 5V tolerant. 1.2V range. Low speed."
io8_hslv_ft_ls_1v8  "General purpose IO with low voltage optimization. 5V tolerant. 1.8V range. Low speed."
io8_hslv_ft_ls_2v5  "General purpose IO with low voltage optimization. 5V tolerant. 2.5V range. Low speed."
io8_i2c_ft_1v2  "General purpose IO with I2C functionality. 5V tolerant. 1.2V range"
io8_i2c_ft_1v8  "General purpose IO with I2C functionality. 5V tolerant. 1.8V range"
io8_i2c_ft_3v3  "General purpose IO with I2C functionality. 5V tolerant. 3.3V range"
[Model Selector] io8_hslv_swp_ft
io8_ft_hs_1v2  "General purpose IO. 5V tolerant. 1.2V range. High speed."
io8_ft_hs_1v8  "General purpose IO. 5V tolerant. 1.8V range. High speed."
io8_ft_hs_3v3  "General purpose IO. 5V tolerant. 3.3V range. High speed."
io8_ft_fs_1v2  "General purpose IO. 5V tolerant. 1.2V range. Fast speed."
io8_ft_fs_1v8  "General purpose IO. 5V tolerant. 1.8V range. Fast speed."
io8_ft_fs_3v3  "General purpose IO. 5V tolerant. 3.3V range. Fast speed."
io8_ft_ms_1v2  "General purpose IO. 5V tolerant. 1.2V range. Medium speed."
io8_ft_ms_1v8  "General purpose IO. 5V tolerant. 1.8V range. Medium speed."
io8_ft_ms_3v3  "General purpose IO. 5V tolerant. 3.3V range. Medium speed."
io8_ft_ls_1v2  "General purpose IO. 5V tolerant. 1.2V range. Low speed."
io8_ft_ls_1v8  "General purpose IO. 5V tolerant. 1.8V range. Low speed."
io8_ft_ls_3v3  "General purpose IO. 5V tolerant. 3.3V range. Low speed."
io8_hslv_ft_hs_1v2  "General purpose IO with low voltage optimization. 5V tolerant. 1.2V range. High speed."
io8_hslv_ft_hs_1v8  "General purpose IO with low voltage optimization. 5V tolerant. 1.8V range. High speed."
io8_hslv_ft_hs_2v5  "General purpose IO with low voltage optimization. 5V tolerant. 2.5V range. High speed."
io8_hslv_ft_fs_1v2  "General purpose IO with low voltage optimization. 5V tolerant. 1.2V range. Fast speed."
io8_hslv_ft_fs_1v8  "General purpose IO with low voltage optimization. 5V tolerant. 1.8V range. Fast speed."
io8_hslv_ft_fs_2v5  "General purpose IO with low voltage optimization. 5V tolerant. 2.5V range. Fast speed."
io8_hslv_ft_ms_1v2  "General purpose IO with low voltage optimization. 5V tolerant. 1.2V range. Medium speed."
io8_hslv_ft_ms_1v8  "General purpose IO with low voltage optimization. 5V tolerant. 1.8V range. Medium speed."
io8_hslv_ft_ms_2v5  "General purpose IO with low voltage optimization. 5V tolerant. 2.5V range. Medium speed."
io8_hslv_ft_ls_1v2  "General purpose IO with low voltage optimization. 5V tolerant. 1.2V range. Low speed."
io8_hslv_ft_ls_1v8  "General purpose IO with low voltage optimization. 5V tolerant. 1.8V range. Low speed."
io8_hslv_ft_ls_2v5  "General purpose IO with low voltage optimization. 5V tolerant. 2.5V range. Low speed."
io8_hslv_swpc_ft  "GP IO with low voltage opt. and SWP C functionality. 5V tolerant. 1.8V range"
io8_hslv_swpb_ft  "GP IO with low voltage opt. and SWP B functionality. 5V tolerant. 3.3V range"
[Model Selector] io8_i2c_ft
io8_i2c_ft_1v2  "General purpose IO with I2C functionality. 5V tolerant. 1.2V range"
io8_i2c_ft_1v8  "General purpose IO with I2C functionality. 5V tolerant. 1.8V range"
io8_i2c_ft_3v3  "General purpose IO with I2C functionality. 5V tolerant. 3.3V range"
[Model Selector] io8usb_id_otg20_ft
io8_ft_hs_1v2  "General purpose IO. 5V tolerant. 1.2V range. High speed."
io8_ft_hs_1v8  "General purpose IO. 5V tolerant. 1.8V range. High speed."
io8_ft_hs_3v3  "General purpose IO. 5V tolerant. 3.3V range. High speed."
io8_ft_fs_1v2  "General purpose IO. 5V tolerant. 1.2V range. Fast speed."
io8_ft_fs_1v8  "General purpose IO. 5V tolerant. 1.8V range. Fast speed."
io8_ft_fs_3v3  "General purpose IO. 5V tolerant. 3.3V range. Fast speed."
io8_ft_ms_1v2  "General purpose IO. 5V tolerant. 1.2V range. Medium speed."
io8_ft_ms_1v8  "General purpose IO. 5V tolerant. 1.8V range. Medium speed."
io8_ft_ms_3v3  "General purpose IO. 5V tolerant. 3.3V range. Medium speed."
io8_ft_ls_1v2  "General purpose IO. 5V tolerant. 1.2V range. Low speed."
io8_ft_ls_1v8  "General purpose IO. 5V tolerant. 1.8V range. Low speed."
io8_ft_ls_3v3  "General purpose IO. 5V tolerant. 3.3V range. Low speed."
io8usb_id_ft_pup  "USB OTG ID PAD. 5V tolerant. With pull up"
io8usb_id_ft_nopup  "USB OTG ID PAD. 5V tolerant. No pull up"
[Model Selector] io8usb_lsfs_bcd_otg20_ft
io8_ft_hs_1v2  "General purpose IO. 5V tolerant. 1.2V range. High speed."
io8_ft_hs_1v8  "General purpose IO. 5V tolerant. 1.8V range. High speed."
io8_ft_hs_3v3  "General purpose IO. 5V tolerant. 3.3V range. High speed."
io8_ft_fs_1v2  "General purpose IO. 5V tolerant. 1.2V range. Fast speed."
io8_ft_fs_1v8  "General purpose IO. 5V tolerant. 1.8V range. Fast speed."
io8_ft_fs_3v3  "General purpose IO. 5V tolerant. 3.3V range. Fast speed."
io8_ft_ms_1v2  "General purpose IO. 5V tolerant. 1.2V range. Medium speed."
io8_ft_ms_1v8  "General purpose IO. 5V tolerant. 1.8V range. Medium speed."
io8_ft_ms_3v3  "General purpose IO. 5V tolerant. 3.3V range. Medium speed."
io8_ft_ls_1v2  "General purpose IO. 5V tolerant. 1.2V range. Low speed."
io8_ft_ls_1v8  "General purpose IO. 5V tolerant. 1.8V range. Low speed."
io8_ft_ls_3v3  "General purpose IO. 5V tolerant. 3.3V range. Low speed."
io8usb_fs_ft_pu2  ""USB full speed + pull up2""
io8usb_fs_ft_pu1  ""USB full speed + pull up1""
io8usb_fs_ft_pd  ""USB full speed + pull down""
io8usb_fs_ft  ""USB full speed""
io8usb_ls_ft_pu2  ""USB low speed + pull up2""
io8usb_ls_ft_pu1  ""USB low speed + pull up1""
io8usb_ls_ft_pd  ""USB low speed + pull down""
io8usb_ls_ft  ""USB low speed""
[Model Selector] io8usb_vbus_otg20_ft
io8_ft_hs_1v2  "General purpose IO. 5V tolerant. 1.2V range. High speed."
io8_ft_hs_1v8  "General purpose IO. 5V tolerant. 1.8V range. High speed."
io8_ft_hs_3v3  "General purpose IO. 5V tolerant. 3.3V range. High speed."
io8_ft_fs_1v2  "General purpose IO. 5V tolerant. 1.2V range. Fast speed."
io8_ft_fs_1v8  "General purpose IO. 5V tolerant. 1.8V range. Fast speed."
io8_ft_fs_3v3  "General purpose IO. 5V tolerant. 3.3V range. Fast speed."
io8_ft_ms_1v2  "General purpose IO. 5V tolerant. 1.2V range. Medium speed."
io8_ft_ms_1v8  "General purpose IO. 5V tolerant. 1.8V range. Medium speed."
io8_ft_ms_3v3  "General purpose IO. 5V tolerant. 3.3V range. Medium speed."
io8_ft_ls_1v2  "General purpose IO. 5V tolerant. 1.2V range. Low speed."
io8_ft_ls_1v8  "General purpose IO. 5V tolerant. 1.8V range. Low speed."
io8_ft_ls_3v3  "General purpose IO. 5V tolerant. 3.3V range. Low speed."
io8usb_adp  "USB Adp no pull up, no pull down"
io8usb_vbus  "USB Vbus"
[Model Selector] ioreset_ft
ioreset_ft_v33_pu_1v2  "Reset PAD - PU on. 5V tolerant. 1.2V range"
ioreset_ft_v33_pu_1v8  "Reset PAD - PU on. 5V tolerant. 1.8V range"
ioreset_ft_v33_pu_3v3  "Reset PAD - PU on. 5V tolerant. 3.3V range"
ioreset_ft_v33_1v2  "Reset PAD. 5V tolerant. 1.2V range"
ioreset_ft_v33_1v8  "Reset PAD. 5V tolerant. 1.8V range"
ioreset_ft_v33_3v3  "Reset PAD. 5V tolerant. 3.3V range"
[Model Selector] vpp_test_hv
vpp_1v2  "Vpp 1V2 range"
vpp_1v8  "Vpp 1v8 range"
vpp_3v3  "Vpp 3V3 range"
[Define Package Model]  stm32h743_753_ufbga_176
[Manufacturer]  Unknown
[OEM]  Unknown
[Description]  None
[Number Of Pins]  153
[Pin Numbers]
| Pin Num   Terminal Name
D6 | BOOT0
J1 | NRST
N3 | PA0
N2 | PA1
P2 | PA2
R2 | PA3
N4 | PA4
P4 | PA5
P3 | PA6
R3 | PA7
F15 | PA8
E15 | PA9
D15 | PA10
C15 | PA11
B15 | PA12
A15 | PA13
A14 | PA14
A13 | PA15
R5 | PB0
R4 | PB1
M6 | PB2
A10 | PB3
A9 | PB4
A6 | PB5
B6 | PB6
B5 | PB7
A5 | PB8
B4 | PB9
R12 | PB10
R13 | PB11
P12 | PB12
P13 | PB13
R14 | PB14
R15 | PB15
M2 | PC0
M3 | PC1
M4 | PC2_C
M5 | PC3_C
N5 | PC4
P5 | PC5
H15 | PC6
G15 | PC7
G14 | PC8
F14 | PC9
B14 | PC10
B13 | PC11
A12 | PC12
D1 | PC13
E1 | PC14
F1 | PC15
B12 | PD0
C12 | PD1
D12 | PD2
D11 | PD3
D10 | PD4
C11 | PD5
B11 | PD6
A11 | PD7
P15 | PD8
P14 | PD9
N15 | PD10
N14 | PD11
N13 | PD12
M15 | PD13
M14 | PD14
L14 | PD15
C6 | PDR_ON
A4 | PE0
A3 | PE1
A2 | PE2
A1 | PE3
B1 | PE4
B2 | PE5
B3 | PE6
R8 | PE7
P8 | PE8
P9 | PE9
R9 | PE10
P10 | PE11
R10 | PE12
N11 | PE13
P11 | PE14
R11 | PE15
E2 | PF0
H3 | PF1
H2 | PF2
J2 | PF3
J3 | PF4
K3 | PF5
K2 | PF6
K1 | PF7
L3 | PF8
L2 | PF9
L1 | PF10
R6 | PF11
P6 | PF12
N6 | PF13
R7 | PF14
P7 | PF15
N7 | PG0
M7 | PG1
L15 | PG2
K15 | PG3
K14 | PG4
K13 | PG5
J15 | PG6
J14 | PG7
H14 | PG8
C10 | PG9
B10 | PG10
B9 | PG11
B8 | PG12
A8 | PG13
A7 | PG14
B7 | PG15
F4 | PH2
G4 | PH3
H4 | PH4
J4 | PH5
M11 | PH6
N12 | PH7
M12 | PH8
M13 | PH9
L13 | PH10
L12 | PH11
K12 | PH12
E12 | PH13
E13 | PH14
D13 | PH15
G1 | PH0
H1 | PH1
E14 | PI0
D14 | PI1
C14 | PI2
C13 | PI3
D4 | PI4
C4 | PI5
C3 | PI6
C2 | PI7
D2 | PI8
D3 | PI9
E3 | PI10
E4 | PI11
C1 | VBAT
M10 | VCAP
F13 | VCAP
C5 | VDD
H13 | VDD33_USB
R1 | VDDA
P1 | VREFP
N1 | VREFM
D5 | VSS
M1 | VSSA
[Model Data]
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[End Model Data]
[End Package Model]
| Models and submodels in the file (50): io8_ft_hs_1v2 (I/O), io8_ft_hs_1v8 (I/O), io8_ft_hs_3v3 (I/O), io8_ft_fs_1v2 (I/O), io8_ft_fs_1v8 (I/O), io8_ft_fs_3v3 (I/O), io8_ft_ms_1v2 (I/O), io8_ft_ms_1v8 (I/O), io8_ft_ms_3v3 (I/O), io8_ft_ls_1v2 (I/O), io8_ft_ls_1v8 (I/O), io8_ft_ls_3v3 (I/O), io8_hslv_ft_hs_1v2 (I/O), io8_hslv_ft_hs_1v8 (I/O), io8_hslv_ft_hs_2v5 (I/O), io8_hslv_ft_fs_1v2 (I/O), io8_hslv_ft_fs_1v8 (I/O), io8_hslv_ft_fs_2v5 (I/O), io8_hslv_ft_ms_1v2 (I/O), io8_hslv_ft_ms_1v8 (I/O), io8_hslv_ft_ms_2v5 (I/O), io8_hslv_ft_ls_1v2 (I/O), io8_hslv_ft_ls_1v8 (I/O), io8_hslv_ft_ls_2v5 (I/O), io8_hslv_swpc_ft (I/O), io8_hslv_swpb_ft (I/O), io8_i2c_ft_1v2 (I/O), io8_i2c_ft_1v8 (I/O), io8_i2c_ft_3v3 (I/O), io8usb_id_ft_pup (Input), io8usb_id_ft_nopup (Input), io8usb_fs_ft_pu2 (I/O), io8usb_fs_ft_pu1 (I/O), io8usb_fs_ft_pd (I/O), io8usb_fs_ft (I/O), io8usb_ls_ft_pu2 (I/O), io8usb_ls_ft_pu1 (I/O), io8usb_ls_ft_pd (I/O), io8usb_ls_ft (I/O), io8usb_adp (I/O), io8usb_vbus (I/O), ioreset_ft_v33_pu_1v2 (I/O_open_drain), ioreset_ft_v33_pu_1v8 (I/O_open_drain), ioreset_ft_v33_pu_3v3 (I/O_open_drain), ioreset_ft_v33_1v2 (I/O_open_drain), ioreset_ft_v33_1v8 (I/O_open_drain), ioreset_ft_v33_3v3 (I/O_open_drain), vpp_1v2 (Input), vpp_1v8 (Input), vpp_3v3 (Input)
