| mt28ew256aba_1p8_it.ibs * IBIS 4.2 Model
| 256Mb Embedded Parallel NOR
| Lithography: 45nm
| This Model is valid for Temperature Range  -40C<=Ta<=85C
| Part Number   VCCQ   Package
| MT28EW256ABA1xJS-xSIT 1.650V-1.950V   JS = 56-pin TSOP, 14 x 20mm
| MT28EW256ABA1xPC-xSIT 1.650V-1.950V   PC = 64-ball LBGA, 11 x 13mm
| MT28EW256ABA1xPN-xSIT 1.650V-1.950V   PN = 56-Ball VFBGA, 7mm x 9mm
[IBIS ver]   4.2
[File name]  mt28ew256aba_1p8_it.ibs
[File Rev]   2.0
[Date]   January 8, 2015
[Source]   From silicon level SPICE model at Micron Technology, Inc.
   For support send e-mail to modelsupport@micron.com
[Notes]   Revision History:
   1.0: July 23, 2014
   - Pre-silicon model from parasitic extracted netlist
   2.0: January 26, 2015
   - Model matched to measurements
   - For the 1.8V voltage DQ models need to have
   longer Vt lengths
   General Notes:
   - L_pin values in the Pin sections are loop inductance and
   include the mutual inductance to appropriate POWER/GND
   return paths.  POWER/GND parasitics are modeled in the
   Package Models.
[Disclaimer]  This software code and all associated documentation, comments
              or other information (collectively "Software") is provided
              "AS IS" without warranty of any kind. MICRON TECHNOLOGY, INC.
              ("MTI") EXPRESSLY DISCLAIMS ALL WARRANTIES EXPRESS OR IMPLIED,
              INCLUDING BUT NOT LIMITED TO, NONINFRINGEMENT OF THIRD PARTY
              RIGHTS, AND ANY IMPLIED WARRANTIES OF MERCHANTABILITY OR
              FITNESS FOR ANY PARTICULAR PURPOSE. MTI DOES NOT WARRANT THAT
              THE SOFTWARE WILL MEET YOUR REQUIREMENTS, OR THAT THE
              OPERATION OF THE SOFTWARE WILL BE UNINTERRUPTED OR ERROR-FREE.
              FURTHERMORE, MTI DOES NOT MAKE ANY REPRESENTATIONS REGARDING
              THE USE OR THE RESULTS OF THE USE OF THE SOFTWARE IN TERMS OF
              ITS CORRECTNESS, ACCURACY, RELIABILITY, OR OTHERWISE. THE
              ENTIRE RISK ARISING OUT OF USE OR PERFORMANCE OF THE SOFTWARE
              REMAINS WITH YOU. IN NO EVENT SHALL MTI, ITS AFFILIATED
              COMPANIES OR THEIR SUPPLIERS BE LIABLE FOR ANY DIRECT,
              INDIRECT, CONSEQUENTIAL, INCIDENTAL, OR SPECIAL DAMAGES
              (INCLUDING, WITHOUT LIMITATION, DAMAGES FOR LOSS OF PROFITS,
              BUSINESS INTERRUPTION, OR LOSS OF INFORMATION) ARISING OUT OF
              YOUR USE OF OR INABILITY TO USE THE SOFTWARE, EVEN IF MTI HAS
              BEEN ADVISED OF THE POSSIBILITY OF SUCH DAMAGES. Because some
              jurisdictions prohibit the exclusion or limitation of
              liability for consequential or incidental damages, the above
              limitation may not apply to you.
[Copyright]   Copyright 2016 Micron Technology, Inc. All rights reserved.
|   COMPONENT: MT28EW256ABA1xJS
[Component]   MT28EW256ABA1xJS
[Manufacturer]  Micron Technology,Inc.
[Package Model] JS_56_pin_TSOP_14_x_20mm
[Package]
|   typ   min   max
R_pkg   118.74m   63.68m   161.74m
L_pkg   7.33nH   4.66nH   9.46nH
C_pkg   0.94pF   0.80pF   1.07pF
[Pin]   signal_name model_name   R_pin   L_pin   C_pin
1   A23   INPUT2   121.06m   9.46nH   0.92pF
2   A22   INPUT2   120.71m   9.33nH   1.07pF
3   A15   INPUT2   117.51m   9.17nH   1.07pF
4   A14   INPUT2   109.84m   8.92nH   1.05pF
5   A13   INPUT2   104.08m   8.74nH   1.03pF
6   A12   INPUT1   100.24m   8.62nH   1.01pF
7   A11   INPUT1   96.01m   8.48nH   0.99pF
8   A10   INPUT1   92.63m   8.36nH   0.98pF
9   A9   INPUT1   91.43m   8.32nH   0.97pF
10   A8   INPUT1   90.64m   8.26nH   0.96pF
11   A19   INPUT1   90.47m   8.25nH   0.95pF
12   A20   INPUT1   91.07m   8.25nH   0.95pF
13   WE#   INPUT2   93.60m   8.31nH   0.95pF
14   RST#   RESET   94.43m   8.44nH   0.90pF
15   A21   INPUT1   92.20m   8.44nH   0.89pF
16   VPP/WP#   POWER
17   RY/BY#   RY_BY   94.55m   8.34nH   0.97pF
18   A18   INPUT1   91.68m   8.28nH   0.97pF
19   A17   INPUT1   90.17m   8.27nH   0.97pF
20   A7   INPUT1   89.38m   8.27nH   0.98pF
21   A6   INPUT1   89.63m   8.30nH   0.98pF
22   A5   INPUT1   89.83m   8.34nH   0.99pF
23   A4   INPUT2   93.42m   8.45nH   1.01pF
24   A3   INPUT2   96.52m   8.57nH   1.02pF
25   A2   INPUT2   98.97m   8.69nH   1.04pF
26   A1   INPUT2   104.75m   8.90nH   1.05pF
27   NC   NC
28   NC   NC
29   VCCQ   POWER
30   NC   NC
31   A0   INPUT1   156.01m   5.38nH   0.95pF
32   CE#   INPUT2   154.80m   4.97nH   0.89pF
33   VSS   GND
34   OE#   INPUT1   145.90m   4.66nH   0.89pF
35   DQ0   DQ   142.51m   5.54nH   0.89pF
36   DQ8   DQ   139.76m   5.84nH   0.87pF
37   DQ1   DQ   139.55m   5.95nH   0.86pF
38   DQ9   DQ   142.54m   5.90nH   0.86pF
39   DQ2   DQ   141.99m   6.03nH   0.85pF
40   DQ10   DQ   140.34m   6.18nH   0.84pF
41   DQ3   DQ   141.73m   6.30nH   0.83pF
42   DQ11   DQ   143.13m   6.40nH   0.80pF
43   VCC   POWER
44   DQ4   DQ   141.37m   6.34nH   0.84pF
45   DQ12   DQ   141.56m   6.33nH   0.84pF
46   DQ5   DQ   143.47m   6.28nH   0.85pF
47   DQ13   DQ   145.77m   6.16nH   0.86pF
48   DQ6   DQ   146.35m   6.05nH   0.87pF
49   DQ14   DQ   145.51m   6.08nH   0.88pF
50   DQ7   DQ   146.10m   5.82nH   0.90pF
51   DQ15   DQ   151.64m   5.01nH   0.92pF
53   BYTE#   INPUT1   160.74m   5.19nH   0.96pF
54   A16   INPUT1   161.74m   6.15nH   0.98pF
55   NC   NC
56   NC   NC
|   COMPONENT: MT28EW256ABA1xPC
[Component]   MT28EW256ABA1xPC
[Manufacturer]  Micron Technology,Inc.
[Package Model] PC_64_ball_LBGA_11x13mm
[Package]
|   typ   min   max
|   typ   min   max
R_pkg   90.95m   71.51m   126.66m
L_pkg   1.56nH   1.17nH   2.27nH
C_pkg   0.79pF   0.56pF   1.15pF
[Pin]   signal_name model_name   R_pin   L_pin   C_pin
A1   NC   NC
A2   A3   INPUT2   75.05m   1.48nH   0.63pF
A3   A7   INPUT1   77.77m   1.50nH   0.65pF
A4   RY/BY#   RY_BY   86.53m   1.68nH   0.72pF
A5   WE   INPUT2   76.04m   1.50nH   0.65pF
A6   A9   INPUT1   80.59m   1.59nH   0.66pF
A7   A13   INPUT2   83.63m   1.63nH   0.66pF
A8   NC   NC
B1   NC   NC
B2   A4   INPUT2   87.14m   1.52nH   0.69pF
B3   A17   INPUT1   84.34m   1.53nH   0.65pF
B4   VPP/WP#   POWER
B5   RST   RESET   79.30m   1.40nH   0.62pF
B6   A8   INPUT2   75.18m   1.35nH   0.66pF
B7   A12   INPUT2   80.02m   1.55nH   0.68pF
B8   A22   INPUT2   92.18m   1.77nH   0.71pF
C1   NC   NC
C2   A2   INPUT2   72.31m   1.21nH   0.61pF
C3   A6   INPUT2   71.51m   1.18nH   0.65pF
C4   A18   INPUT2   108.73m   1.84nH   0.94pF
C5   A21   INPUT2   85.17m   1.40nH   0.85pF
C6   A10   INPUT2   98.04m   1.60nH   0.83pF
C7   A14   INPUT2   96.56m   1.63nH   0.70pF
C8   A23   INPUT2   84.15m   1.42nH   0.56pF
D1   NC   NC
D2   A1   INPUT2   109.57m   1.88nH   0.76pF
D3   A5   INPUT2   109.65m   1.90nH   0.84pF
D4   A20   INPUT2   126.66m   2.27nH   1.02pF
D5   A19   INPUT2   104.48m   1.87nH   0.92pF
D6   A11   INPUT2   103.14m   1.80nH   0.82pF
D7   A15   INPUT2   101.30m   1.74nH   0.79pF
D8   VCCQ   POWER
E1   NC   NC
E2   A0   INPUT2   110.76m   1.94nH   0.92pF
E3   DQ0   DQ   111.05m   1.83nH   0.86pF
E4   DQ2   DQ   111.14m   1.77nH   1.02pF
E5   DQ5   DQ   97.93m   1.61nH   0.94pF
E6   DQ7   DQ   98.55m   1.62nH   0.92pF
E7   A16   INPUT2   105.04m   1.71nH   0.81pF
E8   VSS   GND
F1   VCCQ   POWER
F2   CE#   INPUT2   84.73m   1.38nH   0.72pF
F3   DQ8   DQ   98.70m   1.54nH   0.76pF
F4   DQ10   DQ   101.42m   1.62nH   0.93pF
F5   DQ12   DQ   100.31m   1.55nH   0.90pF
F6   DQ14   DQ   100.67m   1.56nH   0.89pF
F7   BYTE#   INPUT2   85.80m   1.27nH   0.81pF
F8   NC   NC
G1   NC   NC
G2   OE#   INPUT2   78.81m   1.20nH   0.83pF
G3   DQ9   DQ   75.62m   1.17nH   0.78pF
G4   DQ11   DQ   76.80m   1.18nH   0.78pF
G5   VCC   POWER
G6   DQ13   DQ   83.11m   1.41nH   0.86pF
G7   DQ15   DQ   88.69m   1.37nH   0.89pF
G8   NC   NC
H1   NC   NC
H2   VSS   GND
H3   DQ1   DQ   78.27m   1.35nH   0.78pF
H4   DQ3   DQ   104.72m   1.84nH   0.75pF
H5   DQ4   DQ   78.10m   1.34nH   0.76pF
H6   DQ6   DQ   77.54m   1.29nH   0.79pF
H7   VSS   GND
H8   NC   NC
|   COMPONENT: MT28EW256ABA1xPN
[Component]   MT28EW256ABA1xPN
[Manufacturer]  Micron Technology,Inc.
[Package Model] PN_56_Ball_VFBGA_7mm_x_9mm
[Package]
R_pkg   95.17m   70.39m   188.28m
L_pkg   1.50nH   0.99nH   3.31nH
C_pkg   0.62pF   0.39pF   2.40pF
[Pin]   signal_name model_name   R_pin   L_pin   C_pin
A2   A7   INPUT1   74.24m   1.26nH   0.39pF
A4   VPP   POWER
A5   WE   INPUT2   75.20m   1.30nH   0.54pF
A6   A8   INPUT1   77.32m   1.28nH   0.51pF
A7   A11   INPUT1   79.68m   1.34nH   0.48pF
B1   A3   INPUT2   96.27m   1.41nH   0.42pF
B2   A6   INPUT1   76.42m   1.07nH   0.42pF
B3   NC   NC
B4   RST   RESET   101.42m   1.61nH   0.66pF
B5   A23   INPUT2   143.19m   2.64nH   0.61pF
B6   A19   INPUT1   75.99m   1.09nH   0.55pF
B7   A12   INPUT1   73.69m   1.06nH   0.43pF
B8   A15   INPUT2   75.96m   1.15nH   0.41pF
C1   A2   INPUT2   97.51m   1.51nH   0.46pF
C2   A5   INPUT1   78.74m   1.22nH   0.53pF
C3   A18   INPUT1   81.96m   1.29nH   0.57pF
C4   RY_BY   RY_BY   94.89m   1.56nH   0.64pF
C5   A20   INPUT1   90.72m   1.45nH   0.65pF
C6   A9   INPUT1   102.54m   1.59nH   0.64pF
C7   A13   INPUT2   100.70m   1.56nH   0.66pF
C8   A21   INPUT1   188.28m   3.31nH   0.79pF
D1   A1   INPUT2   117.28m   1.97nH   0.55pF
D2   A4   INPUT2   107.11m   1.79nH   0.61pF
D3   A17   INPUT1   110.41m   1.83nH   0.70pF
D6   A10   INPUT1   106.65m   1.82nH   0.73pF
D7   A14   INPUT2   105.70m   1.79nH   0.67pF
D8   A22   INPUT2   121.39m   2.01nH   0.58pF
E1   A0   INPUT1   114.58m   1.93nH   0.56pF
E2   VSS   GND
E3   DQ1   DQ   109.74m   1.70nH   0.71pF
E6   DQ6   DQ   106.26m   1.61nH   0.79pF
E7   NC   NC
E8   A16   INPUT1   113.66m   1.82nH   0.57pF
F1   CE_N   INPUT2   100.52m   1.53nH   0.51pF
F2   OE_N   INPUT1   99.52m   1.37nH   0.56pF
F3   DQ9   DQ   83.64m   1.14nH   0.63pF
F4   DQ3   DQ   97.32m   1.38nH   0.71pF
F5   DQ4   DQ   92.52m   1.31nH   0.63pF
F6   DQ13   DQ   92.31m   1.30nH   0.74pF
F7   DQ15   DQ   91.61m   1.28nH   0.61pF
F8   NC   NC
G1   NC   NC
G2   DQ0   DQ   74.04m   0.99nH   0.49pF
G3   DQ10   DQ   74.87m   1.10nH   0.61pF
G4   VCC   POWER
G5   VCCQ   POWER
G6   DQ12   DQ   88.94m   1.32nH   0.66pF
G7   DQ7   DQ   84.86m   1.18nH   0.55pF
G8   VSS   GND
H2   DQ8   DQ   76.39m   1.24nH   0.52pF
H3   DQ2   DQ   81.56m   1.25nH   0.57pF
H4   DQ11   DQ   79.96m   1.23nH   0.47pF
H5   NC   NC
H6   DQ5   DQ   95.33m   1.66nH   0.58pF
H7   DQ14   DQ   96.55m   1.64nH   0.61pF
|   Model Selector
[Model Selector] DQ
DQ_JS   I/O for JS = 56-pin TSOP, 14 x 20mm
DQ_PC   I/O for PC = 64-ball LBGA, 11 x 13mm
DQ_PN   I/O for PN = 56-Ball VFBGA, 7mm x 9mm
|Sparse Matrix Package Model for 56-pin TSOP, 14 x 20mm (JS)
[Define Package Model] JS_56_pin_TSOP_14_x_20mm
[Manufacturer]   Micron Technology, Inc.
[OEM]   Micron Technology, Inc.
[Description]   56-pin TSOP, 14 x 20mm (JS)
[Number of Pins]   50
[Pin Numbers]
1  | A23
2  | A22
3  | A15
4  | A14
5  | A13
6  | A12
7  | A11
8  | A10
9  | A9
10  | A8
11  | A19
12  | A20
13  | WE#
14  | RST#
15  | A21
16  | VPP/WP#
17  | RY/BY#
18  | A18
19  | A17
20  | A7
21  | A6
22  | A5
23  | A4
24  | A3
25  | A2
26  | A1
29  | VCCQ
31  | A0
32  | CE#
33  | VSS
34  | OE#
35  | DQ0
36  | DQ8
37  | DQ1
38  | DQ9
39  | DQ2
40  | DQ10
41  | DQ3
42  | DQ11
43  | VCC
44  | DQ4
45  | DQ12
46  | DQ5
47  | DQ13
48  | DQ6
49  | DQ14
50  | DQ7
51  | DQ15
53  | BYTE#
54  | A16
[Model Data]
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[End Model Data]
[End Package Model]
|Sparse Matrix Package Model for 64-ball LBGA, 11 x 13mm (PC)
[Define Package Model]  PC_64_ball_LBGA_11x13mm
[Manufacturer]   Micron Technology, Inc.
[OEM]   Micron Technology, Inc.
[Description]   64-ball LBGA, 11 x 13mm (PC)
[Number of Pins] 51
[Pin Numbers]
A2  | A3
A3  | A7
A4  | RY/BY#
A5  | WE
A6  | A9
A7  | A13
B2  | A4
B3  | A17
B4  | VPP/WP#
B5  | RST#
B6  | A8
B7  | A12
B8  | A22
C2  | A2
C3  | A6
C4  | A18
C5  | A21
C6  | A10
C7  | A14
C8  | A23
D2  | A1
D3  | A5
D4  | A20
D5  | A19
D6  | A11
D7  | A15
D8  | VCCQ
E2  | A0
E3  | DQ0
E4  | DQ2
E5  | DQ5
E6  | DQ7
E7  | A16
F1  | VCCQ
F2  | CE#
F3  | DQ8
F4  | DQ10
F5  | DQ12
F6  | DQ14
F7  | BYTE#
G2  | OE#
G3  | DQ9
G4  | DQ11
G5  | VCC
G6  | DQ13
G7  | DQ15
H3  | DQ1
H4  | DQ3
H5  | DQ4
H6  | DQ6
H7  | VSS
[Model Data]
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[End Model Data]
[End Package Model]
|Sparse Matrix Package Model for 56-Ball VFBGA - 7mm x 9mm(PN)
[Define Package Model] PN_56_Ball_VFBGA_7mm_x_9mm
[Manufacturer] Micron Technology, Inc.
[OEM] Micron Technology, Inc.
[Description]  56-Ball VFBGA  7mm x 9mm (PN)
[Number of Pins] 49
[Pin Numbers]
A2  | A7
A4  | VPP/WP#
A5  | WE#
A6  | A8
A7  | A11
B1  | A3
B2  | A6
B4  | RST#
B5  | A23
B6  | A19
B7  | A12
B8  | A15
C1  | A2
C2  | A5
C3  | A18
C4  | RY/BY#
C5  | A20
C6  | A9
C7  | A13
C8  | A21
D1  | A1
D2  | A4
D3  | A17
D6  | A10
D7  | A14
D8  | A22
E1  | A0
E2  | VSS
E3  | DQ1
E6  | DQ6
E8  | A16
F1  | CE#
F2  | OE#
F3  | DQ9
F4  | DQ3
F5  | DQ4
F6  | DQ13
F7  | DQ15
G2  | DQ0
G3  | DQ10
G4  | VCC
G5  | VCCQ
G6  | DQ12
G7  | DQ7
H2  | DQ8
H3  | DQ2
H4  | DQ11
H6  | DQ5
H7  | DQ14
[Model Data]
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[End Model Data]
[End Package Model]
| Models and submodels in the file (7): INPUT1 (Input), INPUT2 (Input), RESET (Input), RY_BY (Open_drain), DQ_JS (I/O), DQ_PC (I/O), DQ_PN (I/O)
