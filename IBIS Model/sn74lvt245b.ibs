| TEXAS INSTRUMENTS INCORPORATED
| Standard Linear and Logic Group
| IBIS Model of SN74LVT245B
| 3.3-V ABT OCTAL BUS TRANSCEIVER WITH 3-STATE OUTPUTS
| This file contains package information for the following:
|  QFN 20-pin (RGY) package as [Component] LVT245M_RGY
|  SOIC 20-pin (DW) package as [Component] LVT245M_DW
|  SOP 20-pin (NS) package as [Component] LVT245M_NS
|  SSOP 20-pin (DB) package as [Component] LVT245M_DB
|  TSSOP 20-pin (PW) package as [Component] LVT245M_PW
|  jrBGA 20-pin (GQN) package as [Component] LVT245M_GQN
|  jrBGA 20-pin (ZQN) package as [Component] LVT245M_ZQN
| This device can be powered at the following Vccs:
|  3.3 volt Vcc
| This file provides unique models under the [Model Selector] for each Vcc.
| For operation at a specific Vcc, select the appropriate model after each
| [Model Selector] keyword.
[IBIS Ver]   3.2
[Comment char]  |_char
[File Name]   sn74lvt245b.ibs
[File Rev]   2.3 | m_die
[Date]   May 15, 2007
[Source]   Data created from TI-SPICE simulations at TI-SLL.
[Notes]   The following is an IBIS list for the SN74LVT245B.
   Please contact sllibis@ti.com with questions and
   comments concerning SLL IBIS models.
   - FILE REV HISTORY
   - 2.3 Release New creation of IBIS file on 6/6/2007
   - Power clamp data deleted as there is no power-clamp diode.
[Disclaimer] Property of Texas Instruments Incorporated.  Unauthorized
                reproduction and/or distribution is strictly prohibited.
                This product is protected under copyright law.
                Created  2007, (C) Copyright  2007, Texas Instruments
                Incorporated, All Rights Reserved
                UNLESS THERE IS A SIGNED, WRITTEN AGREEMENT TO THE
                CONTRARY, TEXAS INSTRUMENTS (TI) IS PROVIDING THE IBIS
                MODELS  AND WITHOUT ANY WARRANTY, EXPRESSED OR
                IMPLIED.  TI assumes no liability for:
                 1) the accuracy of the IBIS models provided to your
                    company;
                 2) the proper functioning of these IBIS Models in your
                    design or for any resulting applications; or
                 3) infringement of patents, copyrights or intellectual
                    property rights resulting from your use of these IBIS
                    models.
                TI provides IBIS Models as a service to our customers.
                You and your company shall not distribute, sell or give
                these models to anyone else without prior written
                permission from TI.
                TI reserves the right to make changes to our products or
                to discontinue any semiconductor product or service
                without notice, and advises our customers to obtain the
                latest version of relevant information to verify, before
                placing orders, that the information being relied on is
                current.
                Please be aware that your receipt and use of the IBIS
                information provided shall serve as acceptance of these
                terms and conditions.  If you do not accept these terms,
                you should return or destroy the IBIS models and any
                other accompanying information immediately.
| Component SN74LVT245B_RGY 20-PIN QFN
[Component]   SN74LVT245B_RGY
[Manufacturer]   Texas Instruments, Inc.
[Package]
|   typ   min   max
R_pkg   5.000e-02   4.600e-02   5.500e-02
L_pkg   1.119e-09   1.025e-09   1.227e-09
C_pkg   3.520e-13   3.440e-13   3.630e-13
[Pin]   signal_name   model_name   R_pin   L_pin   C_pin
1   DIR   LVT245_INDIR   5.200e-02   1.167e-09   3.600e-13
2   A1   LVT245_IO   4.700e-02   1.049e-09   3.440e-13
3   A2   LVT245_IO   4.700e-02   1.055e-09   3.450e-13
4   A3   LVT245_IO   5.000e-02   1.119e-09   3.500e-13
5   A4   LVT245_IO   5.500e-02   1.227e-09   3.600e-13
6   A5   LVT245_IO   5.200e-02   1.167e-09   3.550e-13
7   A6   LVT245_IO   4.900e-02   1.087e-09   3.480e-13
8   A7   LVT245_IO   4.700e-02   1.054e-09   3.460e-13
9   A8   LVT245_IO   4.900e-02   1.091e-09   3.490e-13
10   GND   GND   5.300e-02   1.184e-09   3.620e-13
11   B8   LVT245_IO   5.300e-02   1.181e-09   3.600e-13
12   B7   LVT245_IO   5.000e-02   1.108e-09   3.490e-13
13   B6   LVT245_IO   4.800e-02   1.075e-09   3.470e-13
14   B5   LVT245_IO   5.000e-02   1.107e-09   3.490e-13
15   B4   LVT245_IO   5.400e-02   1.200e-09   3.620e-13
16   B3   LVT245_IO   5.100e-02   1.141e-09   3.570e-13
17   B2   LVT245_IO   4.700e-02   1.043e-09   3.440e-13
18   B1   LVT245_IO   4.600e-02   1.025e-09   3.440e-13
19   NOE   LVT245_INNOE   4.900e-02   1.090e-09   3.490e-13
20   VCC   POWER   5.400e-02   1.204e-09   3.630e-13
| Component SN74LVT245B_DW 20-PIN SOIC
[Component]   SN74LVT245B_DW
[Manufacturer]   Texas Instruments, Inc.
[Package]
|   typ   min   max
R_pkg   3.800e-02   3.300e-02   4.500e-02
L_pkg   5.012e-09   4.110e-09   6.349e-09
C_pkg   7.170e-13   5.300e-13   8.680e-13
[Pin]   signal_name   model_name   R_pin   L_pin   C_pin
1   DIR   LVT245_INDIR   4.200e-02   6.336e-09   8.650e-13
2   A1   LVT245_IO   4.300e-02   5.542e-09   8.670e-13
3   A2   LVT245_IO   3.400e-02   4.714e-09   7.320e-13
4   A3   LVT245_IO   3.400e-02   4.377e-09   5.910e-13
5   A4   LVT245_IO   3.600e-02   4.130e-09   5.330e-13
6   A5   LVT245_IO   3.500e-02   4.111e-09   5.300e-13
7   A6   LVT245_IO   3.400e-02   4.284e-09   5.830e-13
8   A7   LVT245_IO   3.400e-02   4.634e-09   7.260e-13
9   A8   LVT245_IO   4.000e-02   5.518e-09   8.650e-13
10   GND   GND   4.300e-02   6.349e-09   8.660e-13
11   B8   LVT245_IO   4.100e-02   6.281e-09   8.610e-13
12   B7   LVT245_IO   4.500e-02   5.561e-09   8.680e-13
13   B6   LVT245_IO   3.300e-02   4.778e-09   7.420e-13
14   B5   LVT245_IO   3.500e-02   4.414e-09   5.960e-13
15   B4   LVT245_IO   3.500e-02   4.110e-09   5.330e-13
16   B3   LVT245_IO   3.600e-02   4.130e-09   5.330e-13
17   B2   LVT245_IO   3.400e-02   4.377e-09   5.910e-13
18   B1   LVT245_IO   3.400e-02   4.714e-09   7.310e-13
19   NOE   LVT245_INNOE   4.300e-02   5.569e-09   8.680e-13
20   VCC   POWER   4.200e-02   6.308e-09   8.640e-13
| Component SN74LVT245B_NS 20-PIN SOP
[Component]   SN74LVT245B_NS
[Manufacturer]   Texas Instruments, Inc.
[Package]
|   typ   min   max
R_pkg   4.400e-02   2.900e-02   5.800e-02
L_pkg   3.666e-09   2.317e-09   5.115e-09
C_pkg   5.480e-13   3.160e-13   7.250e-13
[Pin]   signal_name   model_name   R_pin   L_pin   C_pin
1   DIR   LVT245_INDIR   5.800e-02   5.115e-09   7.250e-13
2   A1   LVT245_IO   5.300e-02   4.591e-09   7.240e-13
3   A2   LVT245_IO   4.900e-02   3.754e-09   5.720e-13
4   A3   LVT245_IO   2.900e-02   2.549e-09   3.880e-13
5   A4   LVT245_IO   3.100e-02   2.317e-09   3.160e-13
6   A5   LVT245_IO   3.100e-02   2.317e-09   3.160e-13
7   A6   LVT245_IO   2.900e-02   2.556e-09   3.990e-13
8   A7   LVT245_IO   4.900e-02   3.754e-09   5.790e-13
9   A8   LVT245_IO   5.300e-02   4.591e-09   7.240e-13
10   GND   GND   5.800e-02   5.115e-09   7.250e-13
11   B8   LVT245_IO   5.800e-02   5.115e-09   7.250e-13
12   B7   LVT245_IO   5.300e-02   4.591e-09   7.240e-13
13   B6   LVT245_IO   4.900e-02   3.754e-09   5.790e-13
14   B5   LVT245_IO   2.900e-02   2.557e-09   3.990e-13
15   B4   LVT245_IO   3.100e-02   2.317e-09   3.160e-13
16   B3   LVT245_IO   3.100e-02   2.317e-09   3.160e-13
17   B2   LVT245_IO   2.900e-02   2.557e-09   3.990e-13
18   B1   LVT245_IO   4.900e-02   3.754e-09   5.790e-13
19   NOE   LVT245_INNOE   5.300e-02   4.591e-09   7.240e-13
20   VCC   POWER   5.800e-02   5.115e-09   7.250e-13
| Component SN74LVT245B_DB 20-PIN SSOP
[Component]   SN74LVT245B_DB
[Manufacturer]   Texas Instruments, Inc.
[Package]
|   typ   min   max
R_pkg   4.000e-02   3.500e-02   5.100e-02
L_pkg   3.495e-09   3.035e-09   4.314e-09
C_pkg   4.200e-13   3.460e-13   5.020e-13
[Pin]   signal_name   model_name   R_pin   L_pin   C_pin
1   DIR   LVT245_INDIR   4.900e-02   4.310e-09   5.020e-13
2   A1   LVT245_IO   4.800e-02   3.903e-09   4.870e-13
3   A2   LVT245_IO   3.500e-02   3.189e-09   3.960e-13
4   A3   LVT245_IO   3.500e-02   3.036e-09   3.470e-13
5   A4   LVT245_IO   3.500e-02   3.035e-09   3.670e-13
6   A5   LVT245_IO   3.500e-02   3.035e-09   3.670e-13
7   A6   LVT245_IO   3.500e-02   3.036e-09   3.470e-13
8   A7   LVT245_IO   3.500e-02   3.189e-09   3.970e-13
9   A8   LVT245_IO   4.700e-02   3.899e-09   4.880e-13
10   GND   GND   5.100e-02   4.314e-09   5.000e-13
11   B8   LVT245_IO   5.100e-02   4.314e-09   5.000e-13
12   B7   LVT245_IO   4.700e-02   3.899e-09   4.880e-13
13   B6   LVT245_IO   3.500e-02   3.189e-09   3.970e-13
14   B5   LVT245_IO   3.500e-02   3.036e-09   3.460e-13
15   B4   LVT245_IO   3.500e-02   3.035e-09   3.670e-13
16   B3   LVT245_IO   3.500e-02   3.035e-09   3.670e-13
17   B2   LVT245_IO   3.500e-02   3.036e-09   3.460e-13
18   B1   LVT245_IO   3.500e-02   3.189e-09   3.970e-13
19   NOE   LVT245_INNOE   4.700e-02   3.899e-09   4.880e-13
20   VCC   POWER   5.100e-02   4.314e-09   5.020e-13
| Component SN74LVT245B_PW 20-PIN TSSOP
[Component]   SN74LVT245B_PW
[Manufacturer]   Texas Instruments, Inc.
[Package]
|   typ   min   max
R_pkg   5.000e-02   4.200e-02   6.000e-02
L_pkg   2.802e-09   2.248e-09   3.553e-09
C_pkg   3.170e-13   2.020e-13   4.430e-13
[Pin]   signal_name   model_name   R_pin   L_pin   C_pin
1   DIR   LVT245_INDIR   5.500e-02   3.461e-09   4.400e-13
2   A1   LVT245_IO   5.500e-02   3.150e-09   4.010e-13
3   A2   LVT245_IO   4.200e-02   2.619e-09   3.020e-13
4   A3   LVT245_IO   4.500e-02   2.273e-09   2.020e-13
5   A4   LVT245_IO   4.500e-02   2.248e-09   2.240e-13
6   A5   LVT245_IO   4.500e-02   2.273e-09   2.260e-13
7   A6   LVT245_IO   4.400e-02   2.323e-09   2.050e-13
8   A7   LVT245_IO   4.600e-02   2.704e-09   3.070e-13
9   A8   LVT245_IO   6.000e-02   3.265e-09   4.110e-13
10   GND   GND   5.700e-02   3.506e-09   4.360e-13
11   B8   LVT245_IO   5.800e-02   3.553e-09   4.370e-13
12   B7   LVT245_IO   5.800e-02   3.193e-09   4.050e-13
13   B6   LVT245_IO   4.200e-02   2.704e-09   3.110e-13
14   B5   LVT245_IO   4.600e-02   2.392e-09   2.100e-13
15   B4   LVT245_IO   4.700e-02   2.334e-09   2.290e-13
16   B3   LVT245_IO   4.700e-02   2.300e-09   2.270e-13
17   B2   LVT245_IO   4.700e-02   2.349e-09   2.070e-13
18   B1   LVT245_IO   4.500e-02   2.677e-09   3.060e-13
19   NOE   LVT245_INNOE   6.000e-02   3.235e-09   4.060e-13
20   VCC   POWER   5.600e-02   3.487e-09   4.430e-13
| Component SN74LVT245B_GQN 20-PIN JRBGA
[Component]   SN74LVT245B_GQN
[Manufacturer]   Texas Instruments, Inc.
[Package]
|   typ   min   max
R_pkg   4.300e-02   3.300e-02   6.100e-02
L_pkg   1.317e-09   8.960e-10   2.088e-09
C_pkg   1.130e-13   6.400e-14   1.900e-13
[Pin]   signal_name   model_name   R_pin   L_pin   C_pin
1   DIR   LVT245_INDIR   3.800e-02   1.199e-09   1.210e-13
2   A1   LVT245_IO   4.000e-02   1.067e-09   1.020e-13
3   A2   LVT245_IO   6.100e-02   1.999e-09   1.900e-13
4   A3   LVT245_IO   3.300e-02   9.630e-10   7.100e-14
5   A4   LVT245_IO   4.900e-02   1.523e-09   1.230e-13
6   A5   LVT245_IO   3.300e-02   8.960e-10   6.400e-14
7   A6   LVT245_IO   6.100e-02   1.899e-09   1.640e-13
8   A7   LVT245_IO   3.300e-02   8.980e-10   6.700e-14
9   A8   LVT245_IO   4.900e-02   1.514e-09   1.280e-13
10   GND   GND   3.600e-02   1.006e-09   9.400e-14
11   B8   LVT245_IO   4.900e-02   1.683e-09   1.460e-13
12   B7   LVT245_IO   3.300e-02   1.121e-09   8.900e-14
13   B6   LVT245_IO   6.100e-02   2.088e-09   1.730e-13
14   B5   LVT245_IO   3.300e-02   1.027e-09   7.100e-14
15   B4   LVT245_IO   4.900e-02   1.558e-09   1.240e-13
16   B3   LVT245_IO   3.300e-02   9.280e-10   6.700e-14
17   B2   LVT245_IO   6.100e-02   1.921e-09   1.770e-13
18   B1   LVT245_IO   3.300e-02   9.010e-10   7.700e-14
19   NOE   LVT245_INNOE   3.700e-02   9.900e-10   9.800e-14
20   VCC   POWER   3.500e-02   1.168e-09   1.190e-13
| Component SN74LVT245B_ZQN 20-PIN JRBGA
[Component]   SN74LVT245B_ZQN
[Manufacturer]   Texas Instruments, Inc.
[Package]
|   typ   min   max
R_pkg   4.300e-02   3.300e-02   6.100e-02
L_pkg   1.317e-09   8.960e-10   2.088e-09
C_pkg   1.130e-13   6.400e-14   1.900e-13
[Pin]   signal_name   model_name   R_pin   L_pin   C_pin
1   DIR   LVT245_INDIR   3.800e-02   1.199e-09   1.210e-13
2   A1   LVT245_IO   4.000e-02   1.067e-09   1.020e-13
3   A2   LVT245_IO   6.100e-02   1.999e-09   1.900e-13
4   A3   LVT245_IO   3.300e-02   9.630e-10   7.100e-14
5   A4   LVT245_IO   4.900e-02   1.523e-09   1.230e-13
6   A5   LVT245_IO   3.300e-02   8.960e-10   6.400e-14
7   A6   LVT245_IO   6.100e-02   1.899e-09   1.640e-13
8   A7   LVT245_IO   3.300e-02   8.980e-10   6.700e-14
9   A8   LVT245_IO   4.900e-02   1.514e-09   1.280e-13
10   GND   GND   3.600e-02   1.006e-09   9.400e-14
11   B8   LVT245_IO   4.900e-02   1.683e-09   1.460e-13
12   B7   LVT245_IO   3.300e-02   1.121e-09   8.900e-14
13   B6   LVT245_IO   6.100e-02   2.088e-09   1.730e-13
14   B5   LVT245_IO   3.300e-02   1.027e-09   7.100e-14
15   B4   LVT245_IO   4.900e-02   1.558e-09   1.240e-13
16   B3   LVT245_IO   3.300e-02   9.280e-10   6.700e-14
17   B2   LVT245_IO   6.100e-02   1.921e-09   1.770e-13
18   B1   LVT245_IO   3.300e-02   9.010e-10   7.700e-14
19   NOE   LVT245_INNOE   3.700e-02   9.900e-10   9.800e-14
20   VCC   POWER   3.500e-02   1.168e-09   1.190e-13
| Models and submodels in the file (3): LVT245_INNOE (Input), LVT245_INDIR (Input), LVT245_IO (3-state)
